// The Waveguide pattern, reduced: a parent with a wide vector net wiring a *slice* of it into
// a narrower vector port of a child instance.
`include "disciplines.vams"

module vtop(p, q);
    inout [0:3] p;
    inout [0:1] q;
    electrical [0:3] p;
    electrical [0:1] q;
    electrical [0:1] t;

    vmul m1(t, p[0:1], q);

    analog begin
        V(t[0]) <+ 3.0;
        V(t[1]) <+ 5.0;
    end
endmodule
