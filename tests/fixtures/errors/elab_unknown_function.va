// expect: elab
// at: 7:21
// message: unknown function `foo`
module r(p, n);
  inout p, n;
  electrical p, n;
  analog I(p, n) <+ foo(V(p, n));
endmodule
