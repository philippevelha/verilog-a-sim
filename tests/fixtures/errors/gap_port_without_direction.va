// expect: ok
// gap: LRM: every port must be given a direction (`inout p, n;`); this is accepted
module r(p, n);
  electrical p, n;
  analog I(p, n) <+ V(p, n) / 1k;
endmodule
