// expect: parse
// at: 9:31
// message: expected an expression
// poor: `===` is excluded from Verilog-A by Annex C; the message should say so rather than report a stray `=`
module r(p, n);
  inout p, n;
  electrical p, n;
  integer k;
  analog begin k = 1; if (k === 1) I(p,n) <+ V(p,n); end
endmodule
