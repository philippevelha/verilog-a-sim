// expect: elab
// code: E0307
// at: 10:3
// message: parameter `R` is declared more than once
// fixed: 2.18.1 (before: the second default silently won, R = 2k)
module r(p, n);
  inout p, n;
  electrical p, n;
  parameter real R = 1k;
  parameter real R = 2k;
  analog I(p, n) <+ V(p, n) / R;
endmodule
