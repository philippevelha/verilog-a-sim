// expect: pp
// code: E0101
// message: pp_undefined_macro.va:7: undefined macro `RVAL
module r(p, n);
  inout p, n;
  electrical p, n;
  analog I(p, n) <+ V(p, n) / `RVAL;
endmodule
