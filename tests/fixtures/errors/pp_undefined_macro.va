// expect: pp
// message: pp_undefined_macro.va:6: undefined macro `RVAL
module r(p, n);
  inout p, n;
  electrical p, n;
  analog I(p, n) <+ V(p, n) / `RVAL;
endmodule
