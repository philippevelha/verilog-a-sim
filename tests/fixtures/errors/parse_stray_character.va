// expect: parse
// code: E0203
// at: 9:29
// message: found `#`
// fixed: 2.18.2 (before: `found Some(Hash)`)
module r(p, n);
  inout p, n;
  electrical p, n;
  analog I(p, n) <+ V(p, n) # 1k;
endmodule
