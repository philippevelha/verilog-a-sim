// expect: elab
// code: E0341
// at: 8:31
// message: unknown identifier `Rx`
module r(p, n);
  inout p, n;
  electrical p, n;
  analog I(p, n) <+ V(p, n) / Rx;
endmodule
