// expect: pp
// code: E0127
// message: pp_unterminated_string.va:8: this string literal is never closed
// fixed: 2.18.2 (before: a lex error at a byte offset into the preprocessed text, quoting the rest of the file)
module r(p, n);
  inout p, n;
  electrical p, n;
  analog begin $strobe("hi); I(p, n) <+ V(p, n); end
endmodule
