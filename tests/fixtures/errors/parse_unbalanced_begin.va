// expect: parse
// code: E0204
// at: 12:1
// message: expected `end` to close the `begin` opened at
// message: parse_unbalanced_begin.va:10:10
// fixed: 2.18.2 (before: `expected a statement, found Some(EndModule)`, with no mention of the `begin`)
module r(p, n);
  inout p, n;
  electrical p, n;
  analog begin
    I(p, n) <+ V(p, n) / 1k;
endmodule
