// expect: ok
// code: W0302
// warning: this divides two integers
// at: 12:16
// fixed: 2.36.0 (before: accepted silently; 7 / 2 gave 3.5 where Verilog-A gives 3)
module r(p, n);
  inout p, n;
  electrical p, n;
  integer k;
  analog begin
    k = 7;
    I(p, n) <+ (k / 2) * V(p, n);
  end
endmodule
