// expect: elab
// code: E0309
// at: 8:3
// message: parameter `R` value -1 is below its declared minimum 0
module r(p, n);
  inout p, n;
  electrical p, n;
  parameter real R = -1 from (0:inf);
  analog I(p, n) <+ V(p, n) / R;
endmodule
