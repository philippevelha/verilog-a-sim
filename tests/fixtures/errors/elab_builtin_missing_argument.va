// expect: elab
// code: E0333
// at: 9:21
// message: `pow` takes 2 argument(s), but this call passes 1
// fixed: 2.18.1
module r(p, n);
  inout p, n;
  electrical p, n;
  analog I(p, n) <+ pow(V(p, n));
endmodule
