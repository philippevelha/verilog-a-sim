// expect: parse
// code: E0205
// at: 10:34
// message: expected `endmodule` to close module `r`
// message: parse_missing_endmodule.va:7:1
// fixed: 2.18.2 (before: located as `preprocessed line 9`, ending `found None`)
module r(p, n);
  inout p, n;
  electrical p, n;
  analog I(p, n) <+ V(p, n) / 1k;
