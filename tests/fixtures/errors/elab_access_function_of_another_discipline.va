// expect: elab
// code: E0361
// at: 10:10
// message: `Temp(...)` is not an access function of discipline `electrical`
// message: write `V(...)`
// fixed: 2.23.2 (before: accepted; `va-cli sim` then failed with "singular matrix")
module r(p, n);
  inout p, n;
  electrical p, n;
  analog Temp(p, n) <+ V(p, n);
endmodule
