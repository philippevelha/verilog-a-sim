// expect: ok
// at: 5:10
// warning: port `p` has no direction; it is treated as `inout`
// fixed: 2.18.5 (2.18.4 made this an error; it is a warning while the LRM rule is unsettled, see release.txt)
module r(p, n);
  electrical p, n;
  analog I(p, n) <+ V(p, n) / 1k;
endmodule
