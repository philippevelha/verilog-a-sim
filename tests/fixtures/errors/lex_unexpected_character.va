// expect: lex
// code: E0201
// at: 9:29
// message: unexpected character `£`
// fixed: 2.18.2 (before: located by a byte offset into the preprocessed text, and the `£` printed as `Â` because the preprocessor copied it one byte at a time)
module r(p, n);
  inout p, n;
  electrical p, n;
  analog I(p, n) <+ V(p, n) £ 2;
endmodule
