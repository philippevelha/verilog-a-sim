// expect: parse
// code: E023A
// at: 14:19
// message: `break` is not a Verilog-A statement
// fixed: 2.33.0 (before: "expected `=`, found `;`")
module r(p, n);
  inout p, n;
  electrical p, n;
  integer i;
  real x;
  analog begin
    x = 0;
    for (i = 0; i < 4; i = i + 1) begin
      if (i == 2) break;
      x = x + 1;
    end
    I(p, n) <+ x * V(p, n);
  end
endmodule
