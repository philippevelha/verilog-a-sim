// Resonant waveguide optical gyroscope (RWOG): an all-pass microring whose round-trip phase
// carries the Sagnac shift of a rotation rate driven in on an electrical control node.
//
//   in ──►──┬──►── thru          T_thru(phi) = (a^2 - 2 r a cos(phi) + r^2) / (1 - 2 r a cos(phi) + r^2 a^2)
//          ═╪═ r
//        ( ring )                phi = 2*pi*n_eff(lambda)*L/lambda  +  4*pi^2*R^2*Omega/(lambda*c)
//                                                                       ^^^^^^^^^^^^^^^^^^^^^^^^^ Sagnac
//   rot ──►  Omega = V(rot)  (rad/s per volt)
//
// Scheuer, "Quantum and thermal noise limits of coupled resonator optical waveguide and
// resonant waveguide optical rotation sensors", JOSA B 33 (2016) 1827, benchmarks CROW gyros
// against this device. His eq. (13) gives the phase a wave accumulates per round trip in a
// ring of radius R rotating at Omega: `2*pi*R*n*omega/c + 2*pi*R^2*omega*Omega/c^2`. With
// `omega = 2*pi*c/lambda` the second term is the Sagnac phase above — 7.6e-11 rad per rad/s
// for a 30 um ring at 1550 nm, which is why the ring is biased on its resonance *flank*, where
// `dT/dphi` is largest, and why the noise floor decides everything.
//
// The through-port transfer is Bogaerts et al.'s all-pass form (Laser Photon. Rev. 6, 2012,
// eq. 3), with `r` the coupler's self-coupling amplitude and `a` the round-trip amplitude
// transmission. Geometry, dispersion (`ng`) and defaults are `microring.va`'s: L = 188.7193 um
// puts the m = 347 resonance at exactly 1550.000 nm, and the all-pass linewidth is
// `(1 - r a) lambda^2 / (pi n_g L sqrt(r a))` = 0.032 nm (FWHM) for 5 % coupling and 3 dB/cm.
// The steepest flank is at +-FWHM/(2*sqrt(3)) = +-0.0092 nm from resonance.
//
// # Why the rotation rate is a voltage
//
// This netlist format sweeps and references *sources*, and the two questions a gyro designer
// asks are both source questions: `.dc Vrot …` gives the transfer `P_thru(Omega)` and its slope
// — Scheuer's sensitivity `S = (1/P_in) dP_out/dOmega`, eq. (14) — and `.noise V(out) Vrot`
// gives the output noise *referred to the rotation rate*: `sqrt(S_in)` in (rad/s)/sqrt(Hz) is
// the minimum detectable rotation rate per root-hertz, his eq. (15), computed from the actual
// noise sources in the deck (photodiode shot, load Johnson, laser RIN) and the actual
// linearized gain rather than from a formula. `circuits/ring_gyro_noise.net` does both.
//
// # Limitations
//
// Quasi-static, single polarisation, wavelength-independent coupler, no thermal port and no
// thermorefractive noise of the ring itself (the ring's own thermal phase noise is a
// `waveguide`-type term of length L that the papers here do not include for the RWOG —
// Scheuer's "thermal noise" is the detector load's Johnson noise). No counter-propagating
// mode, so no backscatter-induced lock-in. The Sagnac phase is applied to the round-trip phase
// only, which is the single-ring case of Scheuer's Section 4 (no dispersive enhancement is
// claimed or modelled).
`include "constants.vams"
`include "disciplines.vams"
`include "photonic.vams"

module ring_gyro(in, thru, wl, rot);
    inout in, thru, wl, rot;
    optical    in, thru;
    wavelength wl;
    electrical rot;

    parameter real L       = 188.7193e-6 from (0:inf); // round-trip length (m); R = L/(2 pi)
    parameter real neff    = 2.85        from (0:inf); // effective index at lambda0
    parameter real ng      = 4.1         from (0:inf); // group index
    parameter real lambda0 = 1550e-9     from (0:inf); // wavelength neff/ng are quoted at (m)
    parameter real ksq     = 0.05 from (0:1);          // coupler power coupling
    parameter real loss    = 3.0  from [0:inf);        // propagation loss (dB/cm)
    parameter real c0      = 2.99792458e8;             // speed of light (m/s)

    real lam, n, radius, phis, phi, r, a, den, tthru;

    analog begin
        // Same first-iteration guard as `microring.va`: the wavelength net reads 0 until its
        // source has driven it.
        lam    = (Wl(wl) > 0.0) ? Wl(wl) : lambda0;
        n      = neff + (neff - ng) * (lam - lambda0) / lambda0;
        radius = L / `M_TWO_PI;
        // The static round-trip phase is ~2*pi*m, thousands of radians, and the Sagnac shift
        // is ~1e-10 rad per rad/s: added directly, the shift is below the static phase's
        // floating-point resolution (2180 rad * 2e-16 = 4e-13 rad) and a `.dc` sweep of the
        // rotation rate would read as flat — measured before this reduction as exactly zero
        // slope. Reducing the static phase modulo 2*pi first (exact: `floor` of a number this
        // size is exact, and the subtraction is of two nearby doubles) leaves a phase in
        // [0, 2*pi) with 1e-15 rad resolution. The derivative is unaffected (`floor`'s is
        // zero), so `.noise`, which linearizes, was never wrong — only the sweep was.
        phis   = `M_TWO_PI * n * L / lam;
        phi    = phis - `M_TWO_PI * floor(phis / `M_TWO_PI)
               + 4.0 * `M_PI * `M_PI * radius * radius * V(rot) / (lam * c0);
        r      = sqrt(1.0 - ksq);
        a      = pow(10.0, -loss * (L * 100.0) / 20.0);
        den    = 1.0 - 2.0 * r * a * cos(phi) + (r * a) * (r * a);
        tthru  = (a * a - 2.0 * r * a * cos(phi) + r * r) / den;

        Popt(thru) <+ tthru * Popt(in);
    end
endmodule
