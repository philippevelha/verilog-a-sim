// Shockley diode — bring-up model.
// Matches the hand-written reference in va-abi (crates/va-abi/src/reference/diode.rs),
// including its shot noise.
// Static DC model: no junction capacitance, series resistance, or breakdown.
`include "disciplines.vams"
`include "constants.vams"

module diode(anode, cathode);
    inout anode, cathode;
    electrical anode, cathode;
    parameter real Is = 1e-14 from (0:inf);   // saturation current, A
    parameter real N  = 1.0   from (0:inf);   // ideality factor

    real Id;

    analog begin
        Id = Is * (exp(V(anode, cathode) / (N * $vt)) - 1.0);
        I(anode, cathode) <+ Id;
        // Shot noise: 2*q*|Id| A^2/Hz across the junction. Bias-dependent, unlike a resistor's
        // thermal noise -- and *not* the 4kT*gd its own small-signal conductance would suggest
        // (the two differ by a factor of two; see va_abi::noise's module doc). Contributes
        // nothing outside a noise analysis, so the DC/transient/AC answer is unchanged.
        I(anode, cathode) <+ white_noise(2.0 * `P_Q * abs(Id), "shot");
    end
endmodule
