// mwp_noise -- white current noise in the time domain, generated by the model itself.
//
//   every dt = 1/(2*fmax) a new normal deviate x_k of variance psd*fmax is drawn;
//   I(p, n) follows the straight line from x_(k-1) to x_k over that interval.
//
// One-sided power spectral density of the current (A^2/Hz):
//
//   S(f) = psd * sinc^4(f * dt),   sinc(x) = sin(pi x)/(pi x)
//
// flat (within 0.5 dB) up to 0.26*fmax, 1.8 dB down at fmax/2, 7.8 dB at fmax; choose fmax
// at least four times the band of interest. The line between samples lags by one interval dt
// (a pure delay of the noise, without effect on its spectrum).
//
// The time step is 1/(2*fmax) at most; with exactly that step the trapezoidal rule keeps about
// 1/(1 + pi*fc/(2*fmax)) of the noise variance behind a pole at fc: take fmax >= 40*fc for 4 %.
//
// Why it exists: the simulator's own white_noise() is a small-signal source (.noise) and is
// zero in a transient run unless transient noise is switched on in the simulator
// (va-cli --tran-noise). This module is the same thing done inside the language, with
// $rdist_normal: portable, explicit, one instance per noise source, and blind to the
// operating point -- `psd` is a parameter, so shot noise that follows a changing photocurrent
// cannot be written with it. In a .noise run it is the white source of the same density.
// The time step is bounded to dt.
`include "disciplines.vams"
`include "mwp.vams"
module mwp_noise(p, n);
    inout p, n;
    electrical p, n;
    parameter real psd  = 1e-22 from [0:inf);          // one-sided current noise density, A^2/Hz
    parameter real fmax = 50e9  from (0:inf);          // noise bandwidth (sample rate 2*fmax), Hz
    parameter integer seed0 = 1;                       // random seed; give each instance its own
    integer seed;
    real dt, sig, x0, x1, tk;
    analog begin
        dt  = 0.5 / fmax;
        sig = sqrt(psd * fmax);
        @(initial_step) begin
            seed = seed0;
            x0 = 0.0;
            x1 = 0.0;
            tk = 0.0;
        end
        @(timer(dt, dt)) begin
            x0 = x1;
            x1 = $rdist_normal(seed, 0.0, sig);
            tk = $abstime;
        end
        if (analysis("tran")) begin
            I(p, n) <+ x0 + (x1 - x0) * min(($abstime - tk) / dt, 1.0);
            $bound_step(dt);
        end
        I(p, n) <+ white_noise(psd, "white");
    end
endmodule
