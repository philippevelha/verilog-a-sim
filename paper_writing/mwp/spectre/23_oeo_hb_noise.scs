// Second attempt. The first stopped in the stabilization transient: the photodiode's internal node had no
// dynamics (f3db=0) and follows the delay line's piecewise-linear output, which Spectre reports as a
// discontinuity (SPECTRE-16780, then minimum time step). The detector now has a 40 GHz pole, and the
// pinned node is the modulator drive instead of Spectre's own choice (the detector's internal node).
// 23 -- the same oscillator by autonomous harmonic balance, then its phase noise.
//       Reference for the estimate of t04: L(f) = delta/(2 pi f tau)^2 = -104.0 dBc/Hz at 100 kHz (Rt noiseless here, as there).
// STAGE 2: hb/hbnoise parameter names checked against the help text of SPECTRE 24.10.078 (funds, fundfreqs,
// maxharms, tstab, maxsideband, noisetype, noiseout). Not yet run.
// Autonomous form, corrected from this installation's help_hb.txt: a node pair on the hb line marks an
// oscillator, fundfreqs is the frequency guess, the kick source starts it during tstab. Still never run.
simulator lang=spectre
global 0
include "models.scs"
opts options reltol=1e-6 vabstol=1e-9 iabstol=1e-15 temp=27 tnom=27 gmin=1e-18 save=selected

X1 (a_re a_im nu) mwp_laser p_mw=10.0 rin=3.1622776601683794e-16
Vb (vb 0) vsource dc=2
X2 (a_re a_im b_re b_im bb_re bb_im rf 0 vb) mwp_mzm vpi=4 vpi_dc=4 rterm=0
X3 (b_re b_im c_re c_im) mwp_delay td=5.02e-09
Vk (k 0) vsource dc=3
X4 (c_re c_im an k) mwp_pd resp=0.8 f3db=40e9
RL (an 0) resistor r=50.0
G1 (rf 0 an 0) vccs gm=0.25
Rt (rf 0) resistor r=50.0 isnoisy=no
Lt (rf 0) inductor l=1.591549431e-11
Ct (rf 0) capacitor c=1.591549431e-11
// a single kick as a PWL: Spectre refuses a `pulse` source (periodic) in an autonomous analysis (CMI-2208)
Ik (0 rf) isource type=pwl wave=[0 0 10e-12 1e-3 60e-12 1e-3 70e-12 0]
save rf an
hbo (rf 0) hb fundfreqs=[9.97e9] maxharms=[10] tstab=150e-9 pinnode=rf errpreset=conservative
hbn (rf 0) hbnoise start=1e3 stop=1e8 dec=5 maxsideband=10 noisetype=timeaverage noiseout=[pm]
