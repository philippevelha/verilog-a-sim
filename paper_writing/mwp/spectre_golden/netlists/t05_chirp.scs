// t05_chirp -- golden reference for t05 (b): 4 GHz linear-FM chirp in 10 ns around 10 GHz (strobe 1/(14 GHz)/64)
simulator lang=spectre
global 0
include "models.scs"
opts options reltol=1e-6 vabstol=1e-9 iabstol=1e-15 temp=27 tnom=27 gmin=1e-18 save=selected
X1 (a_re a_im nu1) mwp_laser p_mw=2
X2 (l_re l_im nu2) mwp_laser p_mw=2 df=10e9
Vp (vp 0) vsource type=pwl wave=[ \
    0 40 5e-12 39.92004 1e-11 39.84016 1.5e-11 39.76036 2e-11 39.68064 2.5e-11 39.601 \
    3e-11 39.52144 3.5e-11 39.44196 4e-11 39.36256 4.5e-11 39.28324 5e-11 39.204 5.5e-11 39.12484 \
    6e-11 39.04576 6.5e-11 38.96676 7e-11 38.88784 7.5e-11 38.809 8e-11 38.73024 8.5e-11 38.65156 \
    9e-11 38.57296 9.5e-11 38.49444 1e-10 38.416 1.05e-10 38.33764 1.1e-10 38.25936 1.15e-10 38.18116 \
    1.2e-10 38.10304 1.25e-10 38.025 1.3e-10 37.94704 1.35e-10 37.86916 1.4e-10 37.79136 1.45e-10 37.71364 \
    1.5e-10 37.636 1.55e-10 37.55844 1.6e-10 37.48096 1.65e-10 37.40356 1.7e-10 37.32624 1.75e-10 37.249 \
    1.8e-10 37.17184 1.85e-10 37.09476 1.9e-10 37.01776 1.95e-10 36.94084 2e-10 36.864 2.05e-10 36.78724 \
    2.1e-10 36.71056 2.15e-10 36.63396 2.2e-10 36.55744 2.25e-10 36.481 2.3e-10 36.40464 2.35e-10 36.32836 \
    2.4e-10 36.25216 2.45e-10 36.17604 2.5e-10 36.1 2.55e-10 36.02404 2.6e-10 35.94816 2.65e-10 35.87236 \
    2.7e-10 35.79664 2.75e-10 35.721 2.8e-10 35.64544 2.85e-10 35.56996 2.9e-10 35.49456 2.95e-10 35.41924 \
    3e-10 35.344 3.05e-10 35.26884 3.1e-10 35.19376 3.15e-10 35.11876 3.2e-10 35.04384 3.25e-10 34.969 \
    3.3e-10 34.89424 3.35e-10 34.81956 3.4e-10 34.74496 3.45e-10 34.67044 3.5e-10 34.596 3.55e-10 34.52164 \
    3.6e-10 34.44736 3.65e-10 34.37316 3.7e-10 34.29904 3.75e-10 34.225 3.8e-10 34.15104 3.85e-10 34.07716 \
    3.9e-10 34.00336 3.95e-10 33.92964 4e-10 33.856 4.05e-10 33.78244 4.1e-10 33.70896 4.15e-10 33.63556 \
    4.2e-10 33.56224 4.25e-10 33.489 4.3e-10 33.41584 4.35e-10 33.34276 4.4e-10 33.26976 4.45e-10 33.19684 \
    4.5e-10 33.124 4.55e-10 33.05124 4.6e-10 32.97856 4.65e-10 32.90596 4.7e-10 32.83344 4.75e-10 32.761 \
    4.8e-10 32.68864 4.85e-10 32.61636 4.9e-10 32.54416 4.95e-10 32.47204 5e-10 32.4 5.05e-10 32.32804 \
    5.1e-10 32.25616 5.15e-10 32.18436 5.2e-10 32.11264 5.25e-10 32.041 5.3e-10 31.96944 5.35e-10 31.89796 \
    5.4e-10 31.82656 5.45e-10 31.75524 5.5e-10 31.684 5.55e-10 31.61284 5.6e-10 31.54176 5.65e-10 31.47076 \
    5.7e-10 31.39984 5.75e-10 31.329 5.8e-10 31.25824 5.85e-10 31.18756 5.9e-10 31.11696 5.95e-10 31.04644 \
    6e-10 30.976 6.05e-10 30.90564 6.1e-10 30.83536 6.15e-10 30.76516 6.2e-10 30.69504 6.25e-10 30.625 \
    6.3e-10 30.55504 6.35e-10 30.48516 6.4e-10 30.41536 6.45e-10 30.34564 6.5e-10 30.276 6.55e-10 30.20644 \
    6.6e-10 30.13696 6.65e-10 30.06756 6.7e-10 29.99824 6.75e-10 29.929 6.8e-10 29.85984 6.85e-10 29.79076 \
    6.9e-10 29.72176 6.95e-10 29.65284 7e-10 29.584 7.05e-10 29.51524 7.1e-10 29.44656 7.15e-10 29.37796 \
    7.2e-10 29.30944 7.25e-10 29.241 7.3e-10 29.17264 7.35e-10 29.10436 7.4e-10 29.03616 7.45e-10 28.96804 \
    7.5e-10 28.9 7.55e-10 28.83204 7.6e-10 28.76416 7.65e-10 28.69636 7.7e-10 28.62864 7.75e-10 28.561 \
    7.8e-10 28.49344 7.85e-10 28.42596 7.9e-10 28.35856 7.95e-10 28.29124 8e-10 28.224 8.05e-10 28.15684 \
    8.1e-10 28.08976 8.15e-10 28.02276 8.2e-10 27.95584 8.25e-10 27.889 8.3e-10 27.82224 8.35e-10 27.75556 \
    8.4e-10 27.68896 8.45e-10 27.62244 8.5e-10 27.556 8.55e-10 27.48964 8.6e-10 27.42336 8.65e-10 27.35716 \
    8.7e-10 27.29104 8.75e-10 27.225 8.8e-10 27.15904 8.85e-10 27.09316 8.9e-10 27.02736 8.95e-10 26.96164 \
    9e-10 26.896 9.05e-10 26.83044 9.1e-10 26.76496 9.15e-10 26.69956 9.2e-10 26.63424 9.25e-10 26.569 \
    9.3e-10 26.50384 9.35e-10 26.43876 9.4e-10 26.37376 9.45e-10 26.30884 9.5e-10 26.244 9.55e-10 26.17924 \
    9.6e-10 26.11456 9.65e-10 26.04996 9.7e-10 25.98544 9.75e-10 25.921 9.8e-10 25.85664 9.85e-10 25.79236 \
    9.9e-10 25.72816 9.95e-10 25.66404 1e-09 25.6 1.005e-09 25.53604 1.01e-09 25.47216 1.015e-09 25.40836 \
    1.02e-09 25.34464 1.025e-09 25.281 1.03e-09 25.21744 1.035e-09 25.15396 1.04e-09 25.09056 1.045e-09 25.02724 \
    1.05e-09 24.964 1.055e-09 24.90084 1.06e-09 24.83776 1.065e-09 24.77476 1.07e-09 24.71184 1.075e-09 24.649 \
    1.08e-09 24.58624 1.085e-09 24.52356 1.09e-09 24.46096 1.095e-09 24.39844 1.1e-09 24.336 1.105e-09 24.27364 \
    1.11e-09 24.21136 1.115e-09 24.14916 1.12e-09 24.08704 1.125e-09 24.025 1.13e-09 23.96304 1.135e-09 23.90116 \
    1.14e-09 23.83936 1.145e-09 23.77764 1.15e-09 23.716 1.155e-09 23.65444 1.16e-09 23.59296 1.165e-09 23.53156 \
    1.17e-09 23.47024 1.175e-09 23.409 1.18e-09 23.34784 1.185e-09 23.28676 1.19e-09 23.22576 1.195e-09 23.16484 \
    1.2e-09 23.104 1.205e-09 23.04324 1.21e-09 22.98256 1.215e-09 22.92196 1.22e-09 22.86144 1.225e-09 22.801 \
    1.23e-09 22.74064 1.235e-09 22.68036 1.24e-09 22.62016 1.245e-09 22.56004 1.25e-09 22.5 1.255e-09 22.44004 \
    1.26e-09 22.38016 1.265e-09 22.32036 1.27e-09 22.26064 1.275e-09 22.201 1.28e-09 22.14144 1.285e-09 22.08196 \
    1.29e-09 22.02256 1.295e-09 21.96324 1.3e-09 21.904 1.305e-09 21.84484 1.31e-09 21.78576 1.315e-09 21.72676 \
    1.32e-09 21.66784 1.325e-09 21.609 1.33e-09 21.55024 1.335e-09 21.49156 1.34e-09 21.43296 1.345e-09 21.37444 \
    1.35e-09 21.316 1.355e-09 21.25764 1.36e-09 21.19936 1.365e-09 21.14116 1.37e-09 21.08304 1.375e-09 21.025 \
    1.38e-09 20.96704 1.385e-09 20.90916 1.39e-09 20.85136 1.395e-09 20.79364 1.4e-09 20.736 1.405e-09 20.67844 \
    1.41e-09 20.62096 1.415e-09 20.56356 1.42e-09 20.50624 1.425e-09 20.449 1.43e-09 20.39184 1.435e-09 20.33476 \
    1.44e-09 20.27776 1.445e-09 20.22084 1.45e-09 20.164 1.455e-09 20.10724 1.46e-09 20.05056 1.465e-09 19.99396 \
    1.47e-09 19.93744 1.475e-09 19.881 1.48e-09 19.82464 1.485e-09 19.76836 1.49e-09 19.71216 1.495e-09 19.65604 \
    1.5e-09 19.6 1.505e-09 19.54404 1.51e-09 19.48816 1.515e-09 19.43236 1.52e-09 19.37664 1.525e-09 19.321 \
    1.53e-09 19.26544 1.535e-09 19.20996 1.54e-09 19.15456 1.545e-09 19.09924 1.55e-09 19.044 1.555e-09 18.98884 \
    1.56e-09 18.93376 1.565e-09 18.87876 1.57e-09 18.82384 1.575e-09 18.769 1.58e-09 18.71424 1.585e-09 18.65956 \
    1.59e-09 18.60496 1.595e-09 18.55044 1.6e-09 18.496 1.605e-09 18.44164 1.61e-09 18.38736 1.615e-09 18.33316 \
    1.62e-09 18.27904 1.625e-09 18.225 1.63e-09 18.17104 1.635e-09 18.11716 1.64e-09 18.06336 1.645e-09 18.00964 \
    1.65e-09 17.956 1.655e-09 17.90244 1.66e-09 17.84896 1.665e-09 17.79556 1.67e-09 17.74224 1.675e-09 17.689 \
    1.68e-09 17.63584 1.685e-09 17.58276 1.69e-09 17.52976 1.695e-09 17.47684 1.7e-09 17.424 1.705e-09 17.37124 \
    1.71e-09 17.31856 1.715e-09 17.26596 1.72e-09 17.21344 1.725e-09 17.161 1.73e-09 17.10864 1.735e-09 17.05636 \
    1.74e-09 17.00416 1.745e-09 16.95204 1.75e-09 16.9 1.755e-09 16.84804 1.76e-09 16.79616 1.765e-09 16.74436 \
    1.77e-09 16.69264 1.775e-09 16.641 1.78e-09 16.58944 1.785e-09 16.53796 1.79e-09 16.48656 1.795e-09 16.43524 \
    1.8e-09 16.384 1.805e-09 16.33284 1.81e-09 16.28176 1.815e-09 16.23076 1.82e-09 16.17984 1.825e-09 16.129 \
    1.83e-09 16.07824 1.835e-09 16.02756 1.84e-09 15.97696 1.845e-09 15.92644 1.85e-09 15.876 1.855e-09 15.82564 \
    1.86e-09 15.77536 1.865e-09 15.72516 1.87e-09 15.67504 1.875e-09 15.625 1.88e-09 15.57504 1.885e-09 15.52516 \
    1.89e-09 15.47536 1.895e-09 15.42564 1.9e-09 15.376 1.905e-09 15.32644 1.91e-09 15.27696 1.915e-09 15.22756 \
    1.92e-09 15.17824 1.925e-09 15.129 1.93e-09 15.07984 1.935e-09 15.03076 1.94e-09 14.98176 1.945e-09 14.93284 \
    1.95e-09 14.884 1.955e-09 14.83524 1.96e-09 14.78656 1.965e-09 14.73796 1.97e-09 14.68944 1.975e-09 14.641 \
    1.98e-09 14.59264 1.985e-09 14.54436 1.99e-09 14.49616 1.995e-09 14.44804 2e-09 14.4 2.005e-09 14.35204 \
    2.01e-09 14.30416 2.015e-09 14.25636 2.02e-09 14.20864 2.025e-09 14.161 2.03e-09 14.11344 2.035e-09 14.06596 \
    2.04e-09 14.01856 2.045e-09 13.97124 2.05e-09 13.924 2.055e-09 13.87684 2.06e-09 13.82976 2.065e-09 13.78276 \
    2.07e-09 13.73584 2.075e-09 13.689 2.08e-09 13.64224 2.085e-09 13.59556 2.09e-09 13.54896 2.095e-09 13.50244 \
    2.1e-09 13.456 2.105e-09 13.40964 2.11e-09 13.36336 2.115e-09 13.31716 2.12e-09 13.27104 2.125e-09 13.225 \
    2.13e-09 13.17904 2.135e-09 13.13316 2.14e-09 13.08736 2.145e-09 13.04164 2.15e-09 12.996 2.155e-09 12.95044 \
    2.16e-09 12.90496 2.165e-09 12.85956 2.17e-09 12.81424 2.175e-09 12.769 2.18e-09 12.72384 2.185e-09 12.67876 \
    2.19e-09 12.63376 2.195e-09 12.58884 2.2e-09 12.544 2.205e-09 12.49924 2.21e-09 12.45456 2.215e-09 12.40996 \
    2.22e-09 12.36544 2.225e-09 12.321 2.23e-09 12.27664 2.235e-09 12.23236 2.24e-09 12.18816 2.245e-09 12.14404 \
    2.25e-09 12.1 2.255e-09 12.05604 2.26e-09 12.01216 2.265e-09 11.96836 2.27e-09 11.92464 2.275e-09 11.881 \
    2.28e-09 11.83744 2.285e-09 11.79396 2.29e-09 11.75056 2.295e-09 11.70724 2.3e-09 11.664 2.305e-09 11.62084 \
    2.31e-09 11.57776 2.315e-09 11.53476 2.32e-09 11.49184 2.325e-09 11.449 2.33e-09 11.40624 2.335e-09 11.36356 \
    2.34e-09 11.32096 2.345e-09 11.27844 2.35e-09 11.236 2.355e-09 11.19364 2.36e-09 11.15136 2.365e-09 11.10916 \
    2.37e-09 11.06704 2.375e-09 11.025 2.38e-09 10.98304 2.385e-09 10.94116 2.39e-09 10.89936 2.395e-09 10.85764 \
    2.4e-09 10.816 2.405e-09 10.77444 2.41e-09 10.73296 2.415e-09 10.69156 2.42e-09 10.65024 2.425e-09 10.609 \
    2.43e-09 10.56784 2.435e-09 10.52676 2.44e-09 10.48576 2.445e-09 10.44484 2.45e-09 10.404 2.455e-09 10.36324 \
    2.46e-09 10.32256 2.465e-09 10.28196 2.47e-09 10.24144 2.475e-09 10.201 2.48e-09 10.16064 2.485e-09 10.12036 \
    2.49e-09 10.08016 2.495e-09 10.04004 2.5e-09 10 2.505e-09 9.96004 2.51e-09 9.92016 2.515e-09 9.88036 \
    2.52e-09 9.84064 2.525e-09 9.801 2.53e-09 9.76144 2.535e-09 9.72196 2.54e-09 9.68256 2.545e-09 9.64324 \
    2.55e-09 9.604 2.555e-09 9.56484 2.56e-09 9.52576 2.565e-09 9.48676 2.57e-09 9.44784 2.575e-09 9.409 \
    2.58e-09 9.37024 2.585e-09 9.33156 2.59e-09 9.29296 2.595e-09 9.25444 2.6e-09 9.216 2.605e-09 9.17764 \
    2.61e-09 9.13936 2.615e-09 9.10116 2.62e-09 9.06304 2.625e-09 9.025 2.63e-09 8.98704 2.635e-09 8.94916 \
    2.64e-09 8.91136 2.645e-09 8.87364 2.65e-09 8.836 2.655e-09 8.79844 2.66e-09 8.76096 2.665e-09 8.72356 \
    2.67e-09 8.68624 2.675e-09 8.649 2.68e-09 8.61184 2.685e-09 8.57476 2.69e-09 8.53776 2.695e-09 8.50084 \
    2.7e-09 8.464 2.705e-09 8.42724 2.71e-09 8.39056 2.715e-09 8.35396 2.72e-09 8.31744 2.725e-09 8.281 \
    2.73e-09 8.24464 2.735e-09 8.20836 2.74e-09 8.17216 2.745e-09 8.13604 2.75e-09 8.1 2.755e-09 8.06404 \
    2.76e-09 8.02816 2.765e-09 7.99236 2.77e-09 7.95664 2.775e-09 7.921 2.78e-09 7.88544 2.785e-09 7.84996 \
    2.79e-09 7.81456 2.795e-09 7.77924 2.8e-09 7.744 2.805e-09 7.70884 2.81e-09 7.67376 2.815e-09 7.63876 \
    2.82e-09 7.60384 2.825e-09 7.569 2.83e-09 7.53424 2.835e-09 7.49956 2.84e-09 7.46496 2.845e-09 7.43044 \
    2.85e-09 7.396 2.855e-09 7.36164 2.86e-09 7.32736 2.865e-09 7.29316 2.87e-09 7.25904 2.875e-09 7.225 \
    2.88e-09 7.19104 2.885e-09 7.15716 2.89e-09 7.12336 2.895e-09 7.08964 2.9e-09 7.056 2.905e-09 7.02244 \
    2.91e-09 6.98896 2.915e-09 6.95556 2.92e-09 6.92224 2.925e-09 6.889 2.93e-09 6.85584 2.935e-09 6.82276 \
    2.94e-09 6.78976 2.945e-09 6.75684 2.95e-09 6.724 2.955e-09 6.69124 2.96e-09 6.65856 2.965e-09 6.62596 \
    2.97e-09 6.59344 2.975e-09 6.561 2.98e-09 6.52864 2.985e-09 6.49636 2.99e-09 6.46416 2.995e-09 6.43204 \
    3e-09 6.4 3.005e-09 6.36804 3.01e-09 6.33616 3.015e-09 6.30436 3.02e-09 6.27264 3.025e-09 6.241 \
    3.03e-09 6.20944 3.035e-09 6.17796 3.04e-09 6.14656 3.045e-09 6.11524 3.05e-09 6.084 3.055e-09 6.05284 \
    3.06e-09 6.02176 3.065e-09 5.99076 3.07e-09 5.95984 3.075e-09 5.929 3.08e-09 5.89824 3.085e-09 5.86756 \
    3.09e-09 5.83696 3.095e-09 5.80644 3.1e-09 5.776 3.105e-09 5.74564 3.11e-09 5.71536 3.115e-09 5.68516 \
    3.12e-09 5.65504 3.125e-09 5.625 3.13e-09 5.59504 3.135e-09 5.56516 3.14e-09 5.53536 3.145e-09 5.50564 \
    3.15e-09 5.476 3.155e-09 5.44644 3.16e-09 5.41696 3.165e-09 5.38756 3.17e-09 5.35824 3.175e-09 5.329 \
    3.18e-09 5.29984 3.185e-09 5.27076 3.19e-09 5.24176 3.195e-09 5.21284 3.2e-09 5.184 3.205e-09 5.15524 \
    3.21e-09 5.12656 3.215e-09 5.09796 3.22e-09 5.06944 3.225e-09 5.041 3.23e-09 5.01264 3.235e-09 4.98436 \
    3.24e-09 4.95616 3.245e-09 4.92804 3.25e-09 4.9 3.255e-09 4.87204 3.26e-09 4.84416 3.265e-09 4.81636 \
    3.27e-09 4.78864 3.275e-09 4.761 3.28e-09 4.73344 3.285e-09 4.70596 3.29e-09 4.67856 3.295e-09 4.65124 \
    3.3e-09 4.624 3.305e-09 4.59684 3.31e-09 4.56976 3.315e-09 4.54276 3.32e-09 4.51584 3.325e-09 4.489 \
    3.33e-09 4.46224 3.335e-09 4.43556 3.34e-09 4.40896 3.345e-09 4.38244 3.35e-09 4.356 3.355e-09 4.32964 \
    3.36e-09 4.30336 3.365e-09 4.27716 3.37e-09 4.25104 3.375e-09 4.225 3.38e-09 4.19904 3.385e-09 4.17316 \
    3.39e-09 4.14736 3.395e-09 4.12164 3.4e-09 4.096 3.405e-09 4.07044 3.41e-09 4.04496 3.415e-09 4.01956 \
    3.42e-09 3.99424 3.425e-09 3.969 3.43e-09 3.94384 3.435e-09 3.91876 3.44e-09 3.89376 3.445e-09 3.86884 \
    3.45e-09 3.844 3.455e-09 3.81924 3.46e-09 3.79456 3.465e-09 3.76996 3.47e-09 3.74544 3.475e-09 3.721 \
    3.48e-09 3.69664 3.485e-09 3.67236 3.49e-09 3.64816 3.495e-09 3.62404 3.5e-09 3.6 3.505e-09 3.57604 \
    3.51e-09 3.55216 3.515e-09 3.52836 3.52e-09 3.50464 3.525e-09 3.481 3.53e-09 3.45744 3.535e-09 3.43396 \
    3.54e-09 3.41056 3.545e-09 3.38724 3.55e-09 3.364 3.555e-09 3.34084 3.56e-09 3.31776 3.565e-09 3.29476 \
    3.57e-09 3.27184 3.575e-09 3.249 3.58e-09 3.22624 3.585e-09 3.20356 3.59e-09 3.18096 3.595e-09 3.15844 \
    3.6e-09 3.136 3.605e-09 3.11364 3.61e-09 3.09136 3.615e-09 3.06916 3.62e-09 3.04704 3.625e-09 3.025 \
    3.63e-09 3.00304 3.635e-09 2.98116 3.64e-09 2.95936 3.645e-09 2.93764 3.65e-09 2.916 3.655e-09 2.89444 \
    3.66e-09 2.87296 3.665e-09 2.85156 3.67e-09 2.83024 3.675e-09 2.809 3.68e-09 2.78784 3.685e-09 2.76676 \
    3.69e-09 2.74576 3.695e-09 2.72484 3.7e-09 2.704 3.705e-09 2.68324 3.71e-09 2.66256 3.715e-09 2.64196 \
    3.72e-09 2.62144 3.725e-09 2.601 3.73e-09 2.58064 3.735e-09 2.56036 3.74e-09 2.54016 3.745e-09 2.52004 \
    3.75e-09 2.5 3.755e-09 2.48004 3.76e-09 2.46016 3.765e-09 2.44036 3.77e-09 2.42064 3.775e-09 2.401 \
    3.78e-09 2.38144 3.785e-09 2.36196 3.79e-09 2.34256 3.795e-09 2.32324 3.8e-09 2.304 3.805e-09 2.28484 \
    3.81e-09 2.26576 3.815e-09 2.24676 3.82e-09 2.22784 3.825e-09 2.209 3.83e-09 2.19024 3.835e-09 2.17156 \
    3.84e-09 2.15296 3.845e-09 2.13444 3.85e-09 2.116 3.855e-09 2.09764 3.86e-09 2.07936 3.865e-09 2.06116 \
    3.87e-09 2.04304 3.875e-09 2.025 3.88e-09 2.00704 3.885e-09 1.98916 3.89e-09 1.97136 3.895e-09 1.95364 \
    3.9e-09 1.936 3.905e-09 1.91844 3.91e-09 1.90096 3.915e-09 1.88356 3.92e-09 1.86624 3.925e-09 1.849 \
    3.93e-09 1.83184 3.935e-09 1.81476 3.94e-09 1.79776 3.945e-09 1.78084 3.95e-09 1.764 3.955e-09 1.74724 \
    3.96e-09 1.73056 3.965e-09 1.71396 3.97e-09 1.69744 3.975e-09 1.681 3.98e-09 1.66464 3.985e-09 1.64836 \
    3.99e-09 1.63216 3.995e-09 1.61604 4e-09 1.6 4.005e-09 1.58404 4.01e-09 1.56816 4.015e-09 1.55236 \
    4.02e-09 1.53664 4.025e-09 1.521 4.03e-09 1.50544 4.035e-09 1.48996 4.04e-09 1.47456 4.045e-09 1.45924 \
    4.05e-09 1.444 4.055e-09 1.42884 4.06e-09 1.41376 4.065e-09 1.39876 4.07e-09 1.38384 4.075e-09 1.369 \
    4.08e-09 1.35424 4.085e-09 1.33956 4.09e-09 1.32496 4.095e-09 1.31044 4.1e-09 1.296 4.105e-09 1.28164 \
    4.11e-09 1.26736 4.115e-09 1.25316 4.12e-09 1.23904 4.125e-09 1.225 4.13e-09 1.21104 4.135e-09 1.19716 \
    4.14e-09 1.18336 4.145e-09 1.16964 4.15e-09 1.156 4.155e-09 1.14244 4.16e-09 1.12896 4.165e-09 1.11556 \
    4.17e-09 1.10224 4.175e-09 1.089 4.18e-09 1.07584 4.185e-09 1.06276 4.19e-09 1.04976 4.195e-09 1.03684 \
    4.2e-09 1.024 4.205e-09 1.01124 4.21e-09 0.99856 4.215e-09 0.98596 4.22e-09 0.97344 4.225e-09 0.961 \
    4.23e-09 0.94864 4.235e-09 0.93636 4.24e-09 0.92416 4.245e-09 0.91204 4.25e-09 0.9 4.255e-09 0.88804 \
    4.26e-09 0.87616 4.265e-09 0.86436 4.27e-09 0.85264 4.275e-09 0.841 4.28e-09 0.82944 4.285e-09 0.81796 \
    4.29e-09 0.80656 4.295e-09 0.79524 4.3e-09 0.784 4.305e-09 0.77284 4.31e-09 0.76176 4.315e-09 0.75076 \
    4.32e-09 0.73984 4.325e-09 0.729 4.33e-09 0.71824 4.335e-09 0.70756 4.34e-09 0.69696 4.345e-09 0.68644 \
    4.35e-09 0.676 4.355e-09 0.66564 4.36e-09 0.65536 4.365e-09 0.64516 4.37e-09 0.63504 4.375e-09 0.625 \
    4.38e-09 0.61504 4.385e-09 0.60516 4.39e-09 0.59536 4.395e-09 0.58564 4.4e-09 0.576 4.405e-09 0.56644 \
    4.41e-09 0.55696 4.415e-09 0.54756 4.42e-09 0.53824 4.425e-09 0.529 4.43e-09 0.51984 4.435e-09 0.51076 \
    4.44e-09 0.50176 4.445e-09 0.49284 4.45e-09 0.484 4.455e-09 0.47524 4.46e-09 0.46656 4.465e-09 0.45796 \
    4.47e-09 0.44944 4.475e-09 0.441 4.48e-09 0.43264 4.485e-09 0.42436 4.49e-09 0.41616 4.495e-09 0.40804 \
    4.5e-09 0.4 4.505e-09 0.39204 4.51e-09 0.38416 4.515e-09 0.37636 4.52e-09 0.36864 4.525e-09 0.361 \
    4.53e-09 0.35344 4.535e-09 0.34596 4.54e-09 0.33856 4.545e-09 0.33124 4.55e-09 0.324 4.555e-09 0.31684 \
    4.56e-09 0.30976 4.565e-09 0.30276 4.57e-09 0.29584 4.575e-09 0.289 4.58e-09 0.28224 4.585e-09 0.27556 \
    4.59e-09 0.26896 4.595e-09 0.26244 4.6e-09 0.256 4.605e-09 0.24964 4.61e-09 0.24336 4.615e-09 0.23716 \
    4.62e-09 0.23104 4.625e-09 0.225 4.63e-09 0.21904 4.635e-09 0.21316 4.64e-09 0.20736 4.645e-09 0.20164 \
    4.65e-09 0.196 4.655e-09 0.19044 4.66e-09 0.18496 4.665e-09 0.17956 4.67e-09 0.17424 4.675e-09 0.169 \
    4.68e-09 0.16384 4.685e-09 0.15876 4.69e-09 0.15376 4.695e-09 0.14884 4.7e-09 0.144 4.705e-09 0.13924 \
    4.71e-09 0.13456 4.715e-09 0.12996 4.72e-09 0.12544 4.725e-09 0.121 4.73e-09 0.11664 4.735e-09 0.11236 \
    4.74e-09 0.10816 4.745e-09 0.10404 4.75e-09 0.1 4.755e-09 0.09604 4.76e-09 0.09216 4.765e-09 0.08836 \
    4.77e-09 0.08464 4.775e-09 0.081 4.78e-09 0.07744 4.785e-09 0.07396 4.79e-09 0.07056 4.795e-09 0.06724 \
    4.8e-09 0.064 4.805e-09 0.06084 4.81e-09 0.05776 4.815e-09 0.05476 4.82e-09 0.05184 4.825e-09 0.049 \
    4.83e-09 0.04624 4.835e-09 0.04356 4.84e-09 0.04096 4.845e-09 0.03844 4.85e-09 0.036 4.855e-09 0.03364 \
    4.86e-09 0.03136 4.865e-09 0.02916 4.87e-09 0.02704 4.875e-09 0.025 4.88e-09 0.02304 4.885e-09 0.02116 \
    4.89e-09 0.01936 4.895e-09 0.01764 4.9e-09 0.016 4.905e-09 0.01444 4.91e-09 0.01296 4.915e-09 0.01156 \
    4.92e-09 0.01024 4.925e-09 0.009 4.93e-09 0.00784 4.935e-09 0.00676 4.94e-09 0.00576 4.945e-09 0.00484 \
    4.95e-09 0.004 4.955e-09 0.00324 4.96e-09 0.00256 4.965e-09 0.00196 4.97e-09 0.00144 4.975e-09 0.001 \
    4.98e-09 0.00064 4.985e-09 0.00036 4.99e-09 0.00016 4.995e-09 4e-05 5e-09 0 5.005e-09 4e-05 \
    5.01e-09 0.00016 5.015e-09 0.00036 5.02e-09 0.00064 5.025e-09 0.001 5.03e-09 0.00144 5.035e-09 0.00196 \
    5.04e-09 0.00256 5.045e-09 0.00324 5.05e-09 0.004 5.055e-09 0.00484 5.06e-09 0.00576 5.065e-09 0.00676 \
    5.07e-09 0.00784 5.075e-09 0.009 5.08e-09 0.01024 5.085e-09 0.01156 5.09e-09 0.01296 5.095e-09 0.01444 \
    5.1e-09 0.016 5.105e-09 0.01764 5.11e-09 0.01936 5.115e-09 0.02116 5.12e-09 0.02304 5.125e-09 0.025 \
    5.13e-09 0.02704 5.135e-09 0.02916 5.14e-09 0.03136 5.145e-09 0.03364 5.15e-09 0.036 5.155e-09 0.03844 \
    5.16e-09 0.04096 5.165e-09 0.04356 5.17e-09 0.04624 5.175e-09 0.049 5.18e-09 0.05184 5.185e-09 0.05476 \
    5.19e-09 0.05776 5.195e-09 0.06084 5.2e-09 0.064 5.205e-09 0.06724 5.21e-09 0.07056 5.215e-09 0.07396 \
    5.22e-09 0.07744 5.225e-09 0.081 5.23e-09 0.08464 5.235e-09 0.08836 5.24e-09 0.09216 5.245e-09 0.09604 \
    5.25e-09 0.1 5.255e-09 0.10404 5.26e-09 0.10816 5.265e-09 0.11236 5.27e-09 0.11664 5.275e-09 0.121 \
    5.28e-09 0.12544 5.285e-09 0.12996 5.29e-09 0.13456 5.295e-09 0.13924 5.3e-09 0.144 5.305e-09 0.14884 \
    5.31e-09 0.15376 5.315e-09 0.15876 5.32e-09 0.16384 5.325e-09 0.169 5.33e-09 0.17424 5.335e-09 0.17956 \
    5.34e-09 0.18496 5.345e-09 0.19044 5.35e-09 0.196 5.355e-09 0.20164 5.36e-09 0.20736 5.365e-09 0.21316 \
    5.37e-09 0.21904 5.375e-09 0.225 5.38e-09 0.23104 5.385e-09 0.23716 5.39e-09 0.24336 5.395e-09 0.24964 \
    5.4e-09 0.256 5.405e-09 0.26244 5.41e-09 0.26896 5.415e-09 0.27556 5.42e-09 0.28224 5.425e-09 0.289 \
    5.43e-09 0.29584 5.435e-09 0.30276 5.44e-09 0.30976 5.445e-09 0.31684 5.45e-09 0.324 5.455e-09 0.33124 \
    5.46e-09 0.33856 5.465e-09 0.34596 5.47e-09 0.35344 5.475e-09 0.361 5.48e-09 0.36864 5.485e-09 0.37636 \
    5.49e-09 0.38416 5.495e-09 0.39204 5.5e-09 0.4 5.505e-09 0.40804 5.51e-09 0.41616 5.515e-09 0.42436 \
    5.52e-09 0.43264 5.525e-09 0.441 5.53e-09 0.44944 5.535e-09 0.45796 5.54e-09 0.46656 5.545e-09 0.47524 \
    5.55e-09 0.484 5.555e-09 0.49284 5.56e-09 0.50176 5.565e-09 0.51076 5.57e-09 0.51984 5.575e-09 0.529 \
    5.58e-09 0.53824 5.585e-09 0.54756 5.59e-09 0.55696 5.595e-09 0.56644 5.6e-09 0.576 5.605e-09 0.58564 \
    5.61e-09 0.59536 5.615e-09 0.60516 5.62e-09 0.61504 5.625e-09 0.625 5.63e-09 0.63504 5.635e-09 0.64516 \
    5.64e-09 0.65536 5.645e-09 0.66564 5.65e-09 0.676 5.655e-09 0.68644 5.66e-09 0.69696 5.665e-09 0.70756 \
    5.67e-09 0.71824 5.675e-09 0.729 5.68e-09 0.73984 5.685e-09 0.75076 5.69e-09 0.76176 5.695e-09 0.77284 \
    5.7e-09 0.784 5.705e-09 0.79524 5.71e-09 0.80656 5.715e-09 0.81796 5.72e-09 0.82944 5.725e-09 0.841 \
    5.73e-09 0.85264 5.735e-09 0.86436 5.74e-09 0.87616 5.745e-09 0.88804 5.75e-09 0.9 5.755e-09 0.91204 \
    5.76e-09 0.92416 5.765e-09 0.93636 5.77e-09 0.94864 5.775e-09 0.961 5.78e-09 0.97344 5.785e-09 0.98596 \
    5.79e-09 0.99856 5.795e-09 1.01124 5.8e-09 1.024 5.805e-09 1.03684 5.81e-09 1.04976 5.815e-09 1.06276 \
    5.82e-09 1.07584 5.825e-09 1.089 5.83e-09 1.10224 5.835e-09 1.11556 5.84e-09 1.12896 5.845e-09 1.14244 \
    5.85e-09 1.156 5.855e-09 1.16964 5.86e-09 1.18336 5.865e-09 1.19716 5.87e-09 1.21104 5.875e-09 1.225 \
    5.88e-09 1.23904 5.885e-09 1.25316 5.89e-09 1.26736 5.895e-09 1.28164 5.9e-09 1.296 5.905e-09 1.31044 \
    5.91e-09 1.32496 5.915e-09 1.33956 5.92e-09 1.35424 5.925e-09 1.369 5.93e-09 1.38384 5.935e-09 1.39876 \
    5.94e-09 1.41376 5.945e-09 1.42884 5.95e-09 1.444 5.955e-09 1.45924 5.96e-09 1.47456 5.965e-09 1.48996 \
    5.97e-09 1.50544 5.975e-09 1.521 5.98e-09 1.53664 5.985e-09 1.55236 5.99e-09 1.56816 5.995e-09 1.58404 \
    6e-09 1.6 6.005e-09 1.61604 6.01e-09 1.63216 6.015e-09 1.64836 6.02e-09 1.66464 6.025e-09 1.681 \
    6.03e-09 1.69744 6.035e-09 1.71396 6.04e-09 1.73056 6.045e-09 1.74724 6.05e-09 1.764 6.055e-09 1.78084 \
    6.06e-09 1.79776 6.065e-09 1.81476 6.07e-09 1.83184 6.075e-09 1.849 6.08e-09 1.86624 6.085e-09 1.88356 \
    6.09e-09 1.90096 6.095e-09 1.91844 6.1e-09 1.936 6.105e-09 1.95364 6.11e-09 1.97136 6.115e-09 1.98916 \
    6.12e-09 2.00704 6.125e-09 2.025 6.13e-09 2.04304 6.135e-09 2.06116 6.14e-09 2.07936 6.145e-09 2.09764 \
    6.15e-09 2.116 6.155e-09 2.13444 6.16e-09 2.15296 6.165e-09 2.17156 6.17e-09 2.19024 6.175e-09 2.209 \
    6.18e-09 2.22784 6.185e-09 2.24676 6.19e-09 2.26576 6.195e-09 2.28484 6.2e-09 2.304 6.205e-09 2.32324 \
    6.21e-09 2.34256 6.215e-09 2.36196 6.22e-09 2.38144 6.225e-09 2.401 6.23e-09 2.42064 6.235e-09 2.44036 \
    6.24e-09 2.46016 6.245e-09 2.48004 6.25e-09 2.5 6.255e-09 2.52004 6.26e-09 2.54016 6.265e-09 2.56036 \
    6.27e-09 2.58064 6.275e-09 2.601 6.28e-09 2.62144 6.285e-09 2.64196 6.29e-09 2.66256 6.295e-09 2.68324 \
    6.3e-09 2.704 6.305e-09 2.72484 6.31e-09 2.74576 6.315e-09 2.76676 6.32e-09 2.78784 6.325e-09 2.809 \
    6.33e-09 2.83024 6.335e-09 2.85156 6.34e-09 2.87296 6.345e-09 2.89444 6.35e-09 2.916 6.355e-09 2.93764 \
    6.36e-09 2.95936 6.365e-09 2.98116 6.37e-09 3.00304 6.375e-09 3.025 6.38e-09 3.04704 6.385e-09 3.06916 \
    6.39e-09 3.09136 6.395e-09 3.11364 6.4e-09 3.136 6.405e-09 3.15844 6.41e-09 3.18096 6.415e-09 3.20356 \
    6.42e-09 3.22624 6.425e-09 3.249 6.43e-09 3.27184 6.435e-09 3.29476 6.44e-09 3.31776 6.445e-09 3.34084 \
    6.45e-09 3.364 6.455e-09 3.38724 6.46e-09 3.41056 6.465e-09 3.43396 6.47e-09 3.45744 6.475e-09 3.481 \
    6.48e-09 3.50464 6.485e-09 3.52836 6.49e-09 3.55216 6.495e-09 3.57604 6.5e-09 3.6 6.505e-09 3.62404 \
    6.51e-09 3.64816 6.515e-09 3.67236 6.52e-09 3.69664 6.525e-09 3.721 6.53e-09 3.74544 6.535e-09 3.76996 \
    6.54e-09 3.79456 6.545e-09 3.81924 6.55e-09 3.844 6.555e-09 3.86884 6.56e-09 3.89376 6.565e-09 3.91876 \
    6.57e-09 3.94384 6.575e-09 3.969 6.58e-09 3.99424 6.585e-09 4.01956 6.59e-09 4.04496 6.595e-09 4.07044 \
    6.6e-09 4.096 6.605e-09 4.12164 6.61e-09 4.14736 6.615e-09 4.17316 6.62e-09 4.19904 6.625e-09 4.225 \
    6.63e-09 4.25104 6.635e-09 4.27716 6.64e-09 4.30336 6.645e-09 4.32964 6.65e-09 4.356 6.655e-09 4.38244 \
    6.66e-09 4.40896 6.665e-09 4.43556 6.67e-09 4.46224 6.675e-09 4.489 6.68e-09 4.51584 6.685e-09 4.54276 \
    6.69e-09 4.56976 6.695e-09 4.59684 6.7e-09 4.624 6.705e-09 4.65124 6.71e-09 4.67856 6.715e-09 4.70596 \
    6.72e-09 4.73344 6.725e-09 4.761 6.73e-09 4.78864 6.735e-09 4.81636 6.74e-09 4.84416 6.745e-09 4.87204 \
    6.75e-09 4.9 6.755e-09 4.92804 6.76e-09 4.95616 6.765e-09 4.98436 6.77e-09 5.01264 6.775e-09 5.041 \
    6.78e-09 5.06944 6.785e-09 5.09796 6.79e-09 5.12656 6.795e-09 5.15524 6.8e-09 5.184 6.805e-09 5.21284 \
    6.81e-09 5.24176 6.815e-09 5.27076 6.82e-09 5.29984 6.825e-09 5.329 6.83e-09 5.35824 6.835e-09 5.38756 \
    6.84e-09 5.41696 6.845e-09 5.44644 6.85e-09 5.476 6.855e-09 5.50564 6.86e-09 5.53536 6.865e-09 5.56516 \
    6.87e-09 5.59504 6.875e-09 5.625 6.88e-09 5.65504 6.885e-09 5.68516 6.89e-09 5.71536 6.895e-09 5.74564 \
    6.9e-09 5.776 6.905e-09 5.80644 6.91e-09 5.83696 6.915e-09 5.86756 6.92e-09 5.89824 6.925e-09 5.929 \
    6.93e-09 5.95984 6.935e-09 5.99076 6.94e-09 6.02176 6.945e-09 6.05284 6.95e-09 6.084 6.955e-09 6.11524 \
    6.96e-09 6.14656 6.965e-09 6.17796 6.97e-09 6.20944 6.975e-09 6.241 6.98e-09 6.27264 6.985e-09 6.30436 \
    6.99e-09 6.33616 6.995e-09 6.36804 7e-09 6.4 7.005e-09 6.43204 7.01e-09 6.46416 7.015e-09 6.49636 \
    7.02e-09 6.52864 7.025e-09 6.561 7.03e-09 6.59344 7.035e-09 6.62596 7.04e-09 6.65856 7.045e-09 6.69124 \
    7.05e-09 6.724 7.055e-09 6.75684 7.06e-09 6.78976 7.065e-09 6.82276 7.07e-09 6.85584 7.075e-09 6.889 \
    7.08e-09 6.92224 7.085e-09 6.95556 7.09e-09 6.98896 7.095e-09 7.02244 7.1e-09 7.056 7.105e-09 7.08964 \
    7.11e-09 7.12336 7.115e-09 7.15716 7.12e-09 7.19104 7.125e-09 7.225 7.13e-09 7.25904 7.135e-09 7.29316 \
    7.14e-09 7.32736 7.145e-09 7.36164 7.15e-09 7.396 7.155e-09 7.43044 7.16e-09 7.46496 7.165e-09 7.49956 \
    7.17e-09 7.53424 7.175e-09 7.569 7.18e-09 7.60384 7.185e-09 7.63876 7.19e-09 7.67376 7.195e-09 7.70884 \
    7.2e-09 7.744 7.205e-09 7.77924 7.21e-09 7.81456 7.215e-09 7.84996 7.22e-09 7.88544 7.225e-09 7.921 \
    7.23e-09 7.95664 7.235e-09 7.99236 7.24e-09 8.02816 7.245e-09 8.06404 7.25e-09 8.1 7.255e-09 8.13604 \
    7.26e-09 8.17216 7.265e-09 8.20836 7.27e-09 8.24464 7.275e-09 8.281 7.28e-09 8.31744 7.285e-09 8.35396 \
    7.29e-09 8.39056 7.295e-09 8.42724 7.3e-09 8.464 7.305e-09 8.50084 7.31e-09 8.53776 7.315e-09 8.57476 \
    7.32e-09 8.61184 7.325e-09 8.649 7.33e-09 8.68624 7.335e-09 8.72356 7.34e-09 8.76096 7.345e-09 8.79844 \
    7.35e-09 8.836 7.355e-09 8.87364 7.36e-09 8.91136 7.365e-09 8.94916 7.37e-09 8.98704 7.375e-09 9.025 \
    7.38e-09 9.06304 7.385e-09 9.10116 7.39e-09 9.13936 7.395e-09 9.17764 7.4e-09 9.216 7.405e-09 9.25444 \
    7.41e-09 9.29296 7.415e-09 9.33156 7.42e-09 9.37024 7.425e-09 9.409 7.43e-09 9.44784 7.435e-09 9.48676 \
    7.44e-09 9.52576 7.445e-09 9.56484 7.45e-09 9.604 7.455e-09 9.64324 7.46e-09 9.68256 7.465e-09 9.72196 \
    7.47e-09 9.76144 7.475e-09 9.801 7.48e-09 9.84064 7.485e-09 9.88036 7.49e-09 9.92016 7.495e-09 9.96004 \
    7.5e-09 10 7.505e-09 10.04004 7.51e-09 10.08016 7.515e-09 10.12036 7.52e-09 10.16064 7.525e-09 10.201 \
    7.53e-09 10.24144 7.535e-09 10.28196 7.54e-09 10.32256 7.545e-09 10.36324 7.55e-09 10.404 7.555e-09 10.44484 \
    7.56e-09 10.48576 7.565e-09 10.52676 7.57e-09 10.56784 7.575e-09 10.609 7.58e-09 10.65024 7.585e-09 10.69156 \
    7.59e-09 10.73296 7.595e-09 10.77444 7.6e-09 10.816 7.605e-09 10.85764 7.61e-09 10.89936 7.615e-09 10.94116 \
    7.62e-09 10.98304 7.625e-09 11.025 7.63e-09 11.06704 7.635e-09 11.10916 7.64e-09 11.15136 7.645e-09 11.19364 \
    7.65e-09 11.236 7.655e-09 11.27844 7.66e-09 11.32096 7.665e-09 11.36356 7.67e-09 11.40624 7.675e-09 11.449 \
    7.68e-09 11.49184 7.685e-09 11.53476 7.69e-09 11.57776 7.695e-09 11.62084 7.7e-09 11.664 7.705e-09 11.70724 \
    7.71e-09 11.75056 7.715e-09 11.79396 7.72e-09 11.83744 7.725e-09 11.881 7.73e-09 11.92464 7.735e-09 11.96836 \
    7.74e-09 12.01216 7.745e-09 12.05604 7.75e-09 12.1 7.755e-09 12.14404 7.76e-09 12.18816 7.765e-09 12.23236 \
    7.77e-09 12.27664 7.775e-09 12.321 7.78e-09 12.36544 7.785e-09 12.40996 7.79e-09 12.45456 7.795e-09 12.49924 \
    7.8e-09 12.544 7.805e-09 12.58884 7.81e-09 12.63376 7.815e-09 12.67876 7.82e-09 12.72384 7.825e-09 12.769 \
    7.83e-09 12.81424 7.835e-09 12.85956 7.84e-09 12.90496 7.845e-09 12.95044 7.85e-09 12.996 7.855e-09 13.04164 \
    7.86e-09 13.08736 7.865e-09 13.13316 7.87e-09 13.17904 7.875e-09 13.225 7.88e-09 13.27104 7.885e-09 13.31716 \
    7.89e-09 13.36336 7.895e-09 13.40964 7.9e-09 13.456 7.905e-09 13.50244 7.91e-09 13.54896 7.915e-09 13.59556 \
    7.92e-09 13.64224 7.925e-09 13.689 7.93e-09 13.73584 7.935e-09 13.78276 7.94e-09 13.82976 7.945e-09 13.87684 \
    7.95e-09 13.924 7.955e-09 13.97124 7.96e-09 14.01856 7.965e-09 14.06596 7.97e-09 14.11344 7.975e-09 14.161 \
    7.98e-09 14.20864 7.985e-09 14.25636 7.99e-09 14.30416 7.995e-09 14.35204 8e-09 14.4 8.005e-09 14.44804 \
    8.01e-09 14.49616 8.015e-09 14.54436 8.02e-09 14.59264 8.025e-09 14.641 8.03e-09 14.68944 8.035e-09 14.73796 \
    8.04e-09 14.78656 8.045e-09 14.83524 8.05e-09 14.884 8.055e-09 14.93284 8.06e-09 14.98176 8.065e-09 15.03076 \
    8.07e-09 15.07984 8.075e-09 15.129 8.08e-09 15.17824 8.085e-09 15.22756 8.09e-09 15.27696 8.095e-09 15.32644 \
    8.1e-09 15.376 8.105e-09 15.42564 8.11e-09 15.47536 8.115e-09 15.52516 8.12e-09 15.57504 8.125e-09 15.625 \
    8.13e-09 15.67504 8.135e-09 15.72516 8.14e-09 15.77536 8.145e-09 15.82564 8.15e-09 15.876 8.155e-09 15.92644 \
    8.16e-09 15.97696 8.165e-09 16.02756 8.17e-09 16.07824 8.175e-09 16.129 8.18e-09 16.17984 8.185e-09 16.23076 \
    8.19e-09 16.28176 8.195e-09 16.33284 8.2e-09 16.384 8.205e-09 16.43524 8.21e-09 16.48656 8.215e-09 16.53796 \
    8.22e-09 16.58944 8.225e-09 16.641 8.23e-09 16.69264 8.235e-09 16.74436 8.24e-09 16.79616 8.245e-09 16.84804 \
    8.25e-09 16.9 8.255e-09 16.95204 8.26e-09 17.00416 8.265e-09 17.05636 8.27e-09 17.10864 8.275e-09 17.161 \
    8.28e-09 17.21344 8.285e-09 17.26596 8.29e-09 17.31856 8.295e-09 17.37124 8.3e-09 17.424 8.305e-09 17.47684 \
    8.31e-09 17.52976 8.315e-09 17.58276 8.32e-09 17.63584 8.325e-09 17.689 8.33e-09 17.74224 8.335e-09 17.79556 \
    8.34e-09 17.84896 8.345e-09 17.90244 8.35e-09 17.956 8.355e-09 18.00964 8.36e-09 18.06336 8.365e-09 18.11716 \
    8.37e-09 18.17104 8.375e-09 18.225 8.38e-09 18.27904 8.385e-09 18.33316 8.39e-09 18.38736 8.395e-09 18.44164 \
    8.4e-09 18.496 8.405e-09 18.55044 8.41e-09 18.60496 8.415e-09 18.65956 8.42e-09 18.71424 8.425e-09 18.769 \
    8.43e-09 18.82384 8.435e-09 18.87876 8.44e-09 18.93376 8.445e-09 18.98884 8.45e-09 19.044 8.455e-09 19.09924 \
    8.46e-09 19.15456 8.465e-09 19.20996 8.47e-09 19.26544 8.475e-09 19.321 8.48e-09 19.37664 8.485e-09 19.43236 \
    8.49e-09 19.48816 8.495e-09 19.54404 8.5e-09 19.6 8.505e-09 19.65604 8.51e-09 19.71216 8.515e-09 19.76836 \
    8.52e-09 19.82464 8.525e-09 19.881 8.53e-09 19.93744 8.535e-09 19.99396 8.54e-09 20.05056 8.545e-09 20.10724 \
    8.55e-09 20.164 8.555e-09 20.22084 8.56e-09 20.27776 8.565e-09 20.33476 8.57e-09 20.39184 8.575e-09 20.449 \
    8.58e-09 20.50624 8.585e-09 20.56356 8.59e-09 20.62096 8.595e-09 20.67844 8.6e-09 20.736 8.605e-09 20.79364 \
    8.61e-09 20.85136 8.615e-09 20.90916 8.62e-09 20.96704 8.625e-09 21.025 8.63e-09 21.08304 8.635e-09 21.14116 \
    8.64e-09 21.19936 8.645e-09 21.25764 8.65e-09 21.316 8.655e-09 21.37444 8.66e-09 21.43296 8.665e-09 21.49156 \
    8.67e-09 21.55024 8.675e-09 21.609 8.68e-09 21.66784 8.685e-09 21.72676 8.69e-09 21.78576 8.695e-09 21.84484 \
    8.7e-09 21.904 8.705e-09 21.96324 8.71e-09 22.02256 8.715e-09 22.08196 8.72e-09 22.14144 8.725e-09 22.201 \
    8.73e-09 22.26064 8.735e-09 22.32036 8.74e-09 22.38016 8.745e-09 22.44004 8.75e-09 22.5 8.755e-09 22.56004 \
    8.76e-09 22.62016 8.765e-09 22.68036 8.77e-09 22.74064 8.775e-09 22.801 8.78e-09 22.86144 8.785e-09 22.92196 \
    8.79e-09 22.98256 8.795e-09 23.04324 8.8e-09 23.104 8.805e-09 23.16484 8.81e-09 23.22576 8.815e-09 23.28676 \
    8.82e-09 23.34784 8.825e-09 23.409 8.83e-09 23.47024 8.835e-09 23.53156 8.84e-09 23.59296 8.845e-09 23.65444 \
    8.85e-09 23.716 8.855e-09 23.77764 8.86e-09 23.83936 8.865e-09 23.90116 8.87e-09 23.96304 8.875e-09 24.025 \
    8.88e-09 24.08704 8.885e-09 24.14916 8.89e-09 24.21136 8.895e-09 24.27364 8.9e-09 24.336 8.905e-09 24.39844 \
    8.91e-09 24.46096 8.915e-09 24.52356 8.92e-09 24.58624 8.925e-09 24.649 8.93e-09 24.71184 8.935e-09 24.77476 \
    8.94e-09 24.83776 8.945e-09 24.90084 8.95e-09 24.964 8.955e-09 25.02724 8.96e-09 25.09056 8.965e-09 25.15396 \
    8.97e-09 25.21744 8.975e-09 25.281 8.98e-09 25.34464 8.985e-09 25.40836 8.99e-09 25.47216 8.995e-09 25.53604 \
    9e-09 25.6 9.005e-09 25.66404 9.01e-09 25.72816 9.015e-09 25.79236 9.02e-09 25.85664 9.025e-09 25.921 \
    9.03e-09 25.98544 9.035e-09 26.04996 9.04e-09 26.11456 9.045e-09 26.17924 9.05e-09 26.244 9.055e-09 26.30884 \
    9.06e-09 26.37376 9.065e-09 26.43876 9.07e-09 26.50384 9.075e-09 26.569 9.08e-09 26.63424 9.085e-09 26.69956 \
    9.09e-09 26.76496 9.095e-09 26.83044 9.1e-09 26.896 9.105e-09 26.96164 9.11e-09 27.02736 9.115e-09 27.09316 \
    9.12e-09 27.15904 9.125e-09 27.225 9.13e-09 27.29104 9.135e-09 27.35716 9.14e-09 27.42336 9.145e-09 27.48964 \
    9.15e-09 27.556 9.155e-09 27.62244 9.16e-09 27.68896 9.165e-09 27.75556 9.17e-09 27.82224 9.175e-09 27.889 \
    9.18e-09 27.95584 9.185e-09 28.02276 9.19e-09 28.08976 9.195e-09 28.15684 9.2e-09 28.224 9.205e-09 28.29124 \
    9.21e-09 28.35856 9.215e-09 28.42596 9.22e-09 28.49344 9.225e-09 28.561 9.23e-09 28.62864 9.235e-09 28.69636 \
    9.24e-09 28.76416 9.245e-09 28.83204 9.25e-09 28.9 9.255e-09 28.96804 9.26e-09 29.03616 9.265e-09 29.10436 \
    9.27e-09 29.17264 9.275e-09 29.241 9.28e-09 29.30944 9.285e-09 29.37796 9.29e-09 29.44656 9.295e-09 29.51524 \
    9.3e-09 29.584 9.305e-09 29.65284 9.31e-09 29.72176 9.315e-09 29.79076 9.32e-09 29.85984 9.325e-09 29.929 \
    9.33e-09 29.99824 9.335e-09 30.06756 9.34e-09 30.13696 9.345e-09 30.20644 9.35e-09 30.276 9.355e-09 30.34564 \
    9.36e-09 30.41536 9.365e-09 30.48516 9.37e-09 30.55504 9.375e-09 30.625 9.38e-09 30.69504 9.385e-09 30.76516 \
    9.39e-09 30.83536 9.395e-09 30.90564 9.4e-09 30.976 9.405e-09 31.04644 9.41e-09 31.11696 9.415e-09 31.18756 \
    9.42e-09 31.25824 9.425e-09 31.329 9.43e-09 31.39984 9.435e-09 31.47076 9.44e-09 31.54176 9.445e-09 31.61284 \
    9.45e-09 31.684 9.455e-09 31.75524 9.46e-09 31.82656 9.465e-09 31.89796 9.47e-09 31.96944 9.475e-09 32.041 \
    9.48e-09 32.11264 9.485e-09 32.18436 9.49e-09 32.25616 9.495e-09 32.32804 9.5e-09 32.4 9.505e-09 32.47204 \
    9.51e-09 32.54416 9.515e-09 32.61636 9.52e-09 32.68864 9.525e-09 32.761 9.53e-09 32.83344 9.535e-09 32.90596 \
    9.54e-09 32.97856 9.545e-09 33.05124 9.55e-09 33.124 9.555e-09 33.19684 9.56e-09 33.26976 9.565e-09 33.34276 \
    9.57e-09 33.41584 9.575e-09 33.489 9.58e-09 33.56224 9.585e-09 33.63556 9.59e-09 33.70896 9.595e-09 33.78244 \
    9.6e-09 33.856 9.605e-09 33.92964 9.61e-09 34.00336 9.615e-09 34.07716 9.62e-09 34.15104 9.625e-09 34.225 \
    9.63e-09 34.29904 9.635e-09 34.37316 9.64e-09 34.44736 9.645e-09 34.52164 9.65e-09 34.596 9.655e-09 34.67044 \
    9.66e-09 34.74496 9.665e-09 34.81956 9.67e-09 34.89424 9.675e-09 34.969 9.68e-09 35.04384 9.685e-09 35.11876 \
    9.69e-09 35.19376 9.695e-09 35.26884 9.7e-09 35.344 9.705e-09 35.41924 9.71e-09 35.49456 9.715e-09 35.56996 \
    9.72e-09 35.64544 9.725e-09 35.721 9.73e-09 35.79664 9.735e-09 35.87236 9.74e-09 35.94816 9.745e-09 36.02404 \
    9.75e-09 36.1 9.755e-09 36.17604 9.76e-09 36.25216 9.765e-09 36.32836 9.77e-09 36.40464 9.775e-09 36.481 \
    9.78e-09 36.55744 9.785e-09 36.63396 9.79e-09 36.71056 9.795e-09 36.78724 9.8e-09 36.864 9.805e-09 36.94084 \
    9.81e-09 37.01776 9.815e-09 37.09476 9.82e-09 37.17184 9.825e-09 37.249 9.83e-09 37.32624 9.835e-09 37.40356 \
    9.84e-09 37.48096 9.845e-09 37.55844 9.85e-09 37.636 9.855e-09 37.71364 9.86e-09 37.79136 9.865e-09 37.86916 \
    9.87e-09 37.94704 9.875e-09 38.025 9.88e-09 38.10304 9.885e-09 38.18116 9.89e-09 38.25936 9.895e-09 38.33764 \
    9.9e-09 38.416 9.905e-09 38.49444 9.91e-09 38.57296 9.915e-09 38.65156 9.92e-09 38.73024 9.925e-09 38.809 \
    9.93e-09 38.88784 9.935e-09 38.96676 9.94e-09 39.04576 9.945e-09 39.12484 9.95e-09 39.204 9.955e-09 39.28324 \
    9.96e-09 39.36256 9.965e-09 39.44196 9.97e-09 39.52144 9.975e-09 39.601 9.98e-09 39.68064 9.985e-09 39.76036 \
    9.99e-09 39.84016 9.995e-09 39.92004 1e-08 40 ]
X3 (a_re a_im s_re s_im vp 0) mwp_pm vpi=4 rterm=0
X4 (s_re s_im l_re l_im c_re c_im d_re d_im) mwp_coupler
Vk (k 0) vsource dc=3
X5 (c_re c_im an k) mwp_pd resp=0.8
Vs (an 0) vsource dc=0
save Vs:p
tr tran stop=10e-9 maxstep=1.11607142857e-12 strobeperiod=1.11607142857e-12
