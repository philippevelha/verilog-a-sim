// t11_ladder_sim -- golden reference for t11 (b): 50-section RC ladder, 1 us, Spectre's transient noise: equipartition (strobe 25 ps)
simulator lang=spectre
global 0
include "models.scs"
opts options reltol=1e-6 vabstol=1e-9 iabstol=1e-15 temp=27 tnom=27 gmin=1e-18 save=selected
R0 (0 n0) resistor r=1000
C0 (n0 0) capacitor c=1e-12
R1 (n0 n1) resistor r=1000
C1 (n1 0) capacitor c=1e-12
R2 (n1 n2) resistor r=1000
C2 (n2 0) capacitor c=1e-12
R3 (n2 n3) resistor r=1000
C3 (n3 0) capacitor c=1e-12
R4 (n3 n4) resistor r=1000
C4 (n4 0) capacitor c=1e-12
R5 (n4 n5) resistor r=1000
C5 (n5 0) capacitor c=1e-12
R6 (n5 n6) resistor r=1000
C6 (n6 0) capacitor c=1e-12
R7 (n6 n7) resistor r=1000
C7 (n7 0) capacitor c=1e-12
R8 (n7 n8) resistor r=1000
C8 (n8 0) capacitor c=1e-12
R9 (n8 n9) resistor r=1000
C9 (n9 0) capacitor c=1e-12
R10 (n9 n10) resistor r=1000
C10 (n10 0) capacitor c=1e-12
R11 (n10 n11) resistor r=1000
C11 (n11 0) capacitor c=1e-12
R12 (n11 n12) resistor r=1000
C12 (n12 0) capacitor c=1e-12
R13 (n12 n13) resistor r=1000
C13 (n13 0) capacitor c=1e-12
R14 (n13 n14) resistor r=1000
C14 (n14 0) capacitor c=1e-12
R15 (n14 n15) resistor r=1000
C15 (n15 0) capacitor c=1e-12
R16 (n15 n16) resistor r=1000
C16 (n16 0) capacitor c=1e-12
R17 (n16 n17) resistor r=1000
C17 (n17 0) capacitor c=1e-12
R18 (n17 n18) resistor r=1000
C18 (n18 0) capacitor c=1e-12
R19 (n18 n19) resistor r=1000
C19 (n19 0) capacitor c=1e-12
R20 (n19 n20) resistor r=1000
C20 (n20 0) capacitor c=1e-12
R21 (n20 n21) resistor r=1000
C21 (n21 0) capacitor c=1e-12
R22 (n21 n22) resistor r=1000
C22 (n22 0) capacitor c=1e-12
R23 (n22 n23) resistor r=1000
C23 (n23 0) capacitor c=1e-12
R24 (n23 n24) resistor r=1000
C24 (n24 0) capacitor c=1e-12
R25 (n24 n25) resistor r=1000
C25 (n25 0) capacitor c=1e-12
R26 (n25 n26) resistor r=1000
C26 (n26 0) capacitor c=1e-12
R27 (n26 n27) resistor r=1000
C27 (n27 0) capacitor c=1e-12
R28 (n27 n28) resistor r=1000
C28 (n28 0) capacitor c=1e-12
R29 (n28 n29) resistor r=1000
C29 (n29 0) capacitor c=1e-12
R30 (n29 n30) resistor r=1000
C30 (n30 0) capacitor c=1e-12
R31 (n30 n31) resistor r=1000
C31 (n31 0) capacitor c=1e-12
R32 (n31 n32) resistor r=1000
C32 (n32 0) capacitor c=1e-12
R33 (n32 n33) resistor r=1000
C33 (n33 0) capacitor c=1e-12
R34 (n33 n34) resistor r=1000
C34 (n34 0) capacitor c=1e-12
R35 (n34 n35) resistor r=1000
C35 (n35 0) capacitor c=1e-12
R36 (n35 n36) resistor r=1000
C36 (n36 0) capacitor c=1e-12
R37 (n36 n37) resistor r=1000
C37 (n37 0) capacitor c=1e-12
R38 (n37 n38) resistor r=1000
C38 (n38 0) capacitor c=1e-12
R39 (n38 n39) resistor r=1000
C39 (n39 0) capacitor c=1e-12
R40 (n39 n40) resistor r=1000
C40 (n40 0) capacitor c=1e-12
R41 (n40 n41) resistor r=1000
C41 (n41 0) capacitor c=1e-12
R42 (n41 n42) resistor r=1000
C42 (n42 0) capacitor c=1e-12
R43 (n42 n43) resistor r=1000
C43 (n43 0) capacitor c=1e-12
R44 (n43 n44) resistor r=1000
C44 (n44 0) capacitor c=1e-12
R45 (n44 n45) resistor r=1000
C45 (n45 0) capacitor c=1e-12
R46 (n45 n46) resistor r=1000
C46 (n46 0) capacitor c=1e-12
R47 (n46 n47) resistor r=1000
C47 (n47 0) capacitor c=1e-12
R48 (n47 n48) resistor r=1000
C48 (n48 0) capacitor c=1e-12
R49 (n48 n49) resistor r=1000
C49 (n49 0) capacitor c=1e-12
save n49
tr tran stop=1e-06 maxstep=25e-12 strobeperiod=25e-12 noisefmax=20e9 noiseseed=1
