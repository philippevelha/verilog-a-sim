// t02_filter_tran -- golden reference for t02 (c): filter in transient at 10 GHz, 0.05 V (strobe 1 ps)
simulator lang=spectre
global 0
include "models.scs"
opts options reltol=1e-6 vabstol=1e-9 iabstol=1e-15 temp=27 tnom=27 gmin=1e-18 save=selected
X1 (a_re a_im nu) mwp_laser p_mw=1 nu0=193.4
Vrf (rf 0) vsource type=sine ampl=0.05 freq=10e9
X2 (a_re a_im b_re b_im rf 0) mwp_pm vpi=4 rterm=0
Vt (tune 0) vsource dc=0
X3 (b_re b_im t_re t_im d_re d_im nu tune) mwp_ring nu_res=193.41 q1=4e5 qi=4e5 kf=1e9
Vk (k 0) vsource dc=3
X4 (t_re t_im an k) mwp_pd resp=0.8
Vs (an 0) vsource dc=0
save Vs:p
tr tran stop=6e-9 maxstep=1e-12 strobeperiod=1e-12
