// t08_series_hb -- golden reference for t08: dual-series MZM mixer, RF 10 GHz, LO 9.92 GHz
simulator lang=spectre
global 0
include "models.scs"
opts options reltol=1e-6 vabstol=1e-9 iabstol=1e-15 temp=27 tnom=27 gmin=1e-18 save=selected
X1 (a_re a_im nu) mwp_laser p_mw=10
Vrf (rf 0) vsource type=sine ampl=0.2 freq=10000000000 fundname="frf"
Vlo (lo 0) vsource type=sine ampl=1.5 freq=9920000000 fundname="flo"
Vb (vb 0) vsource dc=2
X2 (a_re a_im b_re b_im x1_re x1_im rf 0 vb) mwp_mzm vpi=4 vpi_dc=4 rterm=0
X3 (b_re b_im c_re c_im x2_re x2_im lo 0 vb) mwp_mzm vpi=4 vpi_dc=4 rterm=0
Vk (k 0) vsource dc=3
X4 (c_re c_im an k) mwp_pd resp=0.8
Vs (an 0) vsource dc=0
save Vs:p
hb1 hb funds=["flo" "frf"] maxharms=[9 5] errpreset=conservative
