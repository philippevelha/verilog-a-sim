// t01_noise -- golden reference for t01 (d): output noise: shot + RIN + load thermal
simulator lang=spectre
global 0
include "models.scs"
opts options reltol=1e-6 vabstol=1e-9 iabstol=1e-15 temp=27 tnom=27 gmin=1e-18 save=selected
X1 (a_re a_im nu) mwp_laser p_mw=10 rin=3.1622776601683794e-16
Vb (vb 0) vsource dc=2
X2 (a_re a_im b_re b_im bb_re bb_im rf 0 vb) mwp_mzm vpi=4 vpi_dc=4 rterm=0
Vk (k 0) vsource dc=3
X3 (b_re b_im an k) mwp_pd resp=0.8
Vrf (rf 0) vsource dc=0 mag=1
RL (an 0) resistor r=50
save an
nz (an 0) noise start=1e8 stop=1e10 dec=2 iprobe=Vrf
