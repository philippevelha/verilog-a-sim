// t06_jitter -- golden reference for t06 (b): the sampler with 100 fs rms timing jitter, 256 pulses (Spectre's $rdist_normal: statistics only)
simulator lang=spectre
global 0
include "models.scs"
opts options reltol=1e-6 vabstol=1e-9 iabstol=1e-15 temp=27 tnom=27 gmin=1e-18 save=selected
X1 (a_re a_im nu) mwp_mll pavg_mw=1 frep=1e9 fwhm=2e-12 t0=0.5e-9 jit=1e-13 seed0=3
Vrf (rf 0) vsource type=sine ampl=0.4 freq=10363281250
Vb (vb 0) vsource dc=2
X2 (a_re a_im b_re b_im bb_re bb_im rf 0 vb) mwp_mzm vpi=4 vpi_dc=4 rterm=0
Vk (k 0) vsource dc=3
X3 (b_re b_im a1 k) mwp_pd resp=0.8
X4 (bb_re bb_im a2 k) mwp_pd resp=0.8
C1 (a1 0) capacitor c=8e-13
C2 (a2 0) capacitor c=8e-13
R1 (a1 0) resistor r=1e13 isnoisy=no
R2 (a2 0) resistor r=1e13 isnoisy=no
save a1 a2
tr tran stop=2.56e-07 strobeperiod=50e-12
