// t10_noise_m30 -- golden reference for t10 (b): signal-spontaneous beat noise at -30 dBm in
simulator lang=spectre
global 0
include "models.scs"
opts options reltol=1e-6 vabstol=1e-9 iabstol=1e-15 temp=27 tnom=27 gmin=1e-18 save=selected
X1 (a_re a_im nu) mwp_laser p_mw=0.001
X2 (a_re a_im b_re b_im) mwp_oamp g0_db=20 psat=10 nf_db=5 nu0=193.4
Vk (k 0) vsource dc=3
X3 (b_re b_im an k) mwp_pd resp=0.8
RL (an 0) resistor r=50
Vd (dummy 0) vsource dc=0 mag=1
Rd (dummy 0) resistor r=1 isnoisy=no
save an
nz (an 0) noise start=1e8 stop=1e10 dec=2 iprobe=Vd
