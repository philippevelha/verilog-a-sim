// t05_qam -- golden reference for t05 (a): 16-QAM at 20 GHz by heterodyning, 32 symbols at 1 GBd, rng seed 7 (strobe T/32)
simulator lang=spectre
global 0
include "models.scs"
opts options reltol=1e-6 vabstol=1e-9 iabstol=1e-15 temp=27 tnom=27 gmin=1e-18 save=selected
X1 (a_re a_im nu1) mwp_laser p_mw=4
X2 (l_re l_im nu2) mwp_laser p_mw=4 df=20e9
Vi (vi 0) vsource type=pwl wave=[ \
    0 1.2 1e-09 1.2 1.1e-09 0.4 2e-09 0.4 2.1e-09 0.4 3e-09 0.4 \
    3.1e-09 1.2 4e-09 1.2 4.1e-09 0.4 5e-09 0.4 5.1e-09 1.2 6e-09 1.2 \
    6.1e-09 1.2 7e-09 1.2 7.1e-09 -1.2 8e-09 -1.2 8.1e-09 -1.2 9e-09 -1.2 \
    9.1e-09 -0.4 1e-08 -0.4 1.01e-08 -0.4 1.1e-08 -0.4 1.11e-08 1.2 1.2e-08 1.2 \
    1.21e-08 1.2 1.3e-08 1.2 1.31e-08 -1.2 1.4e-08 -1.2 1.41e-08 -0.4 1.5e-08 -0.4 \
    1.51e-08 1.2 1.6e-08 1.2 1.61e-08 -1.2 1.7e-08 -1.2 1.71e-08 1.2 1.8e-08 1.2 \
    1.81e-08 -1.2 1.9e-08 -1.2 1.91e-08 -0.4 2e-08 -0.4 2.01e-08 1.2 2.1e-08 1.2 \
    2.11e-08 -0.4 2.2e-08 -0.4 2.21e-08 -0.4 2.3e-08 -0.4 2.31e-08 -0.4 2.4e-08 -0.4 \
    2.41e-08 0.4 2.5e-08 0.4 2.51e-08 -0.4 2.6e-08 -0.4 2.61e-08 1.2 2.7e-08 1.2 \
    2.71e-08 -0.4 2.8e-08 -0.4 2.81e-08 -0.4 2.9e-08 -0.4 2.91e-08 0.4 3e-08 0.4 \
    3.01e-08 0.4 3.1e-08 0.4 3.11e-08 0.4 3.2e-08 0.4 ]
Vq (vq 0) vsource type=pwl wave=[ \
    0 0.4 1e-09 0.4 1.1e-09 1.2 2e-09 1.2 2.1e-09 1.2 3e-09 1.2 \
    3.1e-09 1.2 4e-09 1.2 4.1e-09 0.4 5e-09 0.4 5.1e-09 0.4 6e-09 0.4 \
    6.1e-09 -0.4 7e-09 -0.4 7.1e-09 1.2 8e-09 1.2 8.1e-09 -0.4 9e-09 -0.4 \
    9.1e-09 -1.2 1e-08 -1.2 1.01e-08 1.2 1.1e-08 1.2 1.11e-08 -1.2 1.2e-08 -1.2 \
    1.21e-08 1.2 1.3e-08 1.2 1.31e-08 0.4 1.4e-08 0.4 1.41e-08 -1.2 1.5e-08 -1.2 \
    1.51e-08 -1.2 1.6e-08 -1.2 1.61e-08 -0.4 1.7e-08 -0.4 1.71e-08 -1.2 1.8e-08 -1.2 \
    1.81e-08 -1.2 1.9e-08 -1.2 1.91e-08 0.4 2e-08 0.4 2.01e-08 1.2 2.1e-08 1.2 \
    2.11e-08 -0.4 2.2e-08 -0.4 2.21e-08 1.2 2.3e-08 1.2 2.31e-08 1.2 2.4e-08 1.2 \
    2.41e-08 1.2 2.5e-08 1.2 2.51e-08 0.4 2.6e-08 0.4 2.61e-08 -0.4 2.7e-08 -0.4 \
    2.71e-08 0.4 2.8e-08 0.4 2.81e-08 -0.4 2.9e-08 -0.4 2.91e-08 -0.4 3e-08 -0.4 \
    3.01e-08 -0.4 3.1e-08 -0.4 3.11e-08 -1.2 3.2e-08 -1.2 ]
Vbi (bi 0) vsource dc=4
Vbq (bq 0) vsource dc=4
Vbp (bp 0) vsource dc=2
X3 (a_re a_im s_re s_im vi vq bi bq bp) mwp_iqm vpi=4
X4 (s_re s_im l_re l_im c_re c_im d_re d_im) mwp_coupler
Vk (k 0) vsource dc=3
X5 (c_re c_im an k) mwp_pd resp=0.8
Vs (an 0) vsource dc=0
save Vs:p
tr tran stop=32e-9 maxstep=1.5625e-12 strobeperiod=1.5625e-12
