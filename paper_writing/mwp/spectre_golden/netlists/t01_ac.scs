// t01_ac -- golden reference for t01 (b): small-signal response, modulator 20 GHz and detector 30 GHz poles
simulator lang=spectre
global 0
include "models.scs"
opts options reltol=1e-6 vabstol=1e-9 iabstol=1e-15 temp=27 tnom=27 gmin=1e-18 save=selected
X1 (a_re a_im nu) mwp_laser p_mw=10
Vb (vb 0) vsource dc=2
X2 (a_re a_im b_re b_im bb_re bb_im rf 0 vb) mwp_mzm vpi=4 vpi_dc=4 f3db=20e9
Vk (k 0) vsource dc=3
X3 (b_re b_im an k) mwp_pd resp=0.8 f3db=30e9
Vrf (rf 0) vsource dc=0 mag=1
Vs (an 0) vsource dc=0
save Vs:p
ac1 ac start=1e8 stop=1e11 dec=10
