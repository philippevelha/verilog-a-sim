// t07_ring_allpass -- golden reference for t07 (d): all-pass ring on resonance as an RF delay
simulator lang=spectre
global 0
include "models.scs"
opts options reltol=1e-6 vabstol=1e-9 iabstol=1e-15 temp=27 tnom=27 gmin=1e-18 save=selected
X1 (a_re a_im nu) mwp_laser p_mw=4
Vrf (rf 0) vsource dc=0 mag=1
Vb (vb 0) vsource dc=2
X2 (a_re a_im b_re b_im xx_re xx_im rf 0 vb) mwp_mzm vpi=4 vpi_dc=4 rterm=0
X3 (b_re b_im t_re t_im d_re d_im nu 0) mwp_ring nu_res=193.4 q1=2e4
Vk (k 0) vsource dc=3
X4 (t_re t_im an k) mwp_pd resp=0.8
Vs (an 0) vsource dc=0
save Vs:p
ac1 ac start=1e7 stop=2e10 dec=20
