* 10 Gb/s clock, -0.5..1.5 V, 40 ps transitions (Wang 2016 Fig. 7)
.model pin mrm_pin Cpad=2e-14
Va a 0 PULSE(-0.5 1.5 0 40p 40p 60p 200p)
Vin_re in_re 0 1.0
Vin_im in_im 0 0
Vwl wl 0 1318.813
Vh hp 0 0
N1 a 0 hp 0 in_re in_im th_re th_im dr_re dr_im wl tdt pin
.control
pre_osdi mrm_pin.osdi
set wr_singlescale
set wr_vecnames
option numdgt=10 reltol=1e-5
tran 0.1p 6n 0 0.5p
let ia = -i(Va)*1e3
wrdata f7_trap40_20.dat v(a) ia v(n1#xfc) v(n1#n12) v(n1#n20)
quit
.endc
.end
