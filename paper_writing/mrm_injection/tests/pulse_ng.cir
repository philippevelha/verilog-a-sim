* single pre-emphasis bit
.model pin mrm_pin
Va a 0 PWL(0 0.5 1n 0.5 1.04n 1.7 1.08n 1.7 1.12n 0.9 1.5n 0.9 1.54n -0.3 1.58n -0.3 1.62n 0.5 3n 0.5)
Vin_re in_re 0 1.0
Vin_im in_im 0 0
Vwl wl 0 1318.812
Vh hp 0 0
N1 a 0 hp 0 in_re in_im th_re th_im dr_re dr_im wl tdt pin
.control
pre_osdi mrm_pin.osdi
set wr_singlescale
set wr_vecnames
option numdgt=10 reltol=1e-5
tran 0.1p 3n 0 0.5p
let ia = -i(Va)*1e3
wrdata pulse_ng.dat ia v(n1#xfc) v(n1#n12) v(n1#n20) v(n1#l3) v(th_re) v(th_im)
quit
.endc
.end
