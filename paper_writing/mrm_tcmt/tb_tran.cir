* 25 Gb/s NRZ: behavioural driver -> MRM (depletion mode), ngspice + OSDI
.model drv mrm_driver vlo=0 vhi=2 vth=0.5 f3db=35g Rout=50
.model mrm mrm_tcmt mode=0 lambda0=1550 FSR=10 Qi=20000 Qc=22000 eta_mod=20
+ Rs=100 Cj0=20f Vbi=0.8 Mj=0.5 Cpad=10f dlam_dT=75 Rth=5k Cth=1n Rh0=1k
+ f_abs=0.5 self_heat=1

* data source (logic 0/1), PRBS7, 254 bits
Vd din 0 PWL(0 0 2.4000e-10 0.0 2.4400e-10 1.0 2.8000e-10 1.0 2.8400e-10 0.0 4.8000e-10 0.0 4.8400e-10 1.0 5.6000e-10 1.0 5.6400e-10 0.0 7.2000e-10 0.0 7.2400e-10 1.0 7.6000e-10 1.0 7.6400e-10 0.0 8.0000e-10 0.0 8.0400e-10 1.0 8.4000e-10 1.0 8.4400e-10 0.0 9.6000e-10 0.0 9.6400e-10 1.0 1.1200e-09 1.0 1.1240e-09 0.0 1.2000e-09 0.0 1.2040e-09 1.0 1.2400e-09 1.0 1.2440e-09 0.0 1.3600e-09 0.0 1.3640e-09 1.0 1.4000e-09 1.0 1.4040e-09 0.0 1.4400e-09 0.0 1.4440e-09 1.0 1.5200e-09 1.0 1.5240e-09 0.0 1.6000e-09 0.0 1.6040e-09 1.0 1.7200e-09 1.0 1.7240e-09 0.0 1.7600e-09 0.0 1.7640e-09 1.0 1.8000e-09 1.0 1.8040e-09 0.0 1.8400e-09 0.0 1.8440e-09 1.0 1.8800e-09 1.0 1.8840e-09 0.0 1.9600e-09 0.0 1.9640e-09 1.0 2.1600e-09 1.0 2.1640e-09 0.0 2.2000e-09 0.0 2.2040e-09 1.0 2.2400e-09 1.0 2.2440e-09 0.0 2.4000e-09 0.0 2.4040e-09 1.0 2.5200e-09 1.0 2.5240e-09 0.0 2.6400e-09 0.0 2.6440e-09 1.0 2.6800e-09 1.0 2.6840e-09 0.0 2.7600e-09 0.0 2.7640e-09 1.0 2.8000e-09 1.0 2.8040e-09 0.0 2.8800e-09 0.0 2.8840e-09 1.0 2.9600e-09 1.0 2.9640e-09 0.0 3.0000e-09 0.0 3.0040e-09 1.0 3.0800e-09 1.0 3.0840e-09 0.0 3.1200e-09 0.0 3.1240e-09 1.0 3.1600e-09 1.0 3.1640e-09 0.0 3.2000e-09 0.0 3.2040e-09 1.0 3.2800e-09 1.0 3.2840e-09 0.0 3.3200e-09 0.0 3.3240e-09 1.0 3.4800e-09 1.0 3.4840e-09 0.0 3.5200e-09 0.0 3.5240e-09 1.0 3.6000e-09 1.0 3.6040e-09 0.0 3.7200e-09 0.0 3.7240e-09 1.0 3.8000e-09 1.0 3.8040e-09 0.0 3.8400e-09 0.0 3.8440e-09 1.0 3.8800e-09 1.0 3.8840e-09 0.0 3.9600e-09 0.0 3.9640e-09 1.0 4.0000e-09 1.0 4.0040e-09 0.0 4.0400e-09 0.0 4.0440e-09 1.0 4.1600e-09 1.0 4.1640e-09 0.0 4.2000e-09 0.0 4.2040e-09 1.0 4.3200e-09 1.0 4.3240e-09 0.0 4.4000e-09 0.0 4.4040e-09 1.0 4.4800e-09 1.0 4.4840e-09 0.0 4.5600e-09 0.0 4.5640e-09 1.0 4.6000e-09 1.0 4.6040e-09 0.0 4.6400e-09 0.0 4.6440e-09 1.0 4.6800e-09 1.0 4.6840e-09 0.0 4.7200e-09 0.0 4.7240e-09 1.0 4.7600e-09 1.0 4.7640e-09 0.0 4.8000e-09 0.0 4.8040e-09 1.0 5.0800e-09 1.0 5.0840e-09 0.0 5.3200e-09 0.0 5.3240e-09 1.0 5.3600e-09 1.0 5.3640e-09 0.0 5.5600e-09 0.0 5.5640e-09 1.0 5.6400e-09 1.0 5.6440e-09 0.0 5.8000e-09 0.0 5.8040e-09 1.0 5.8400e-09 1.0 5.8440e-09 0.0 5.8800e-09 0.0 5.8840e-09 1.0 5.9200e-09 1.0 5.9240e-09 0.0 6.0400e-09 0.0 6.0440e-09 1.0 6.2000e-09 1.0 6.2040e-09 0.0 6.2800e-09 0.0 6.2840e-09 1.0 6.3200e-09 1.0 6.3240e-09 0.0 6.4400e-09 0.0 6.4440e-09 1.0 6.4800e-09 1.0 6.4840e-09 0.0 6.5200e-09 0.0 6.5240e-09 1.0 6.6000e-09 1.0 6.6040e-09 0.0 6.6800e-09 0.0 6.6840e-09 1.0 6.8000e-09 1.0 6.8040e-09 0.0 6.8400e-09 0.0 6.8440e-09 1.0 6.8800e-09 1.0 6.8840e-09 0.0 6.9200e-09 0.0 6.9240e-09 1.0 6.9600e-09 1.0 6.9640e-09 0.0 7.0400e-09 0.0 7.0440e-09 1.0 7.2400e-09 1.0 7.2440e-09 0.0 7.2800e-09 0.0 7.2840e-09 1.0 7.3200e-09 1.0 7.3240e-09 0.0 7.4800e-09 0.0 7.4840e-09 1.0 7.6000e-09 1.0 7.6040e-09 0.0 7.7200e-09 0.0 7.7240e-09 1.0 7.7600e-09 1.0 7.7640e-09 0.0 7.8400e-09 0.0 7.8440e-09 1.0 7.8800e-09 1.0 7.8840e-09 0.0 7.9600e-09 0.0 7.9640e-09 1.0 8.0400e-09 1.0 8.0440e-09 0.0 8.0800e-09 0.0 8.0840e-09 1.0 8.1600e-09 1.0 8.1640e-09 0.0 8.2000e-09 0.0 8.2040e-09 1.0 8.2400e-09 1.0 8.2440e-09 0.0 8.2800e-09 0.0 8.2840e-09 1.0 8.3600e-09 1.0 8.3640e-09 0.0 8.4000e-09 0.0 8.4040e-09 1.0 8.5600e-09 1.0 8.5640e-09 0.0 8.6000e-09 0.0 8.6040e-09 1.0 8.6800e-09 1.0 8.6840e-09 0.0 8.8000e-09 0.0 8.8040e-09 1.0 8.8800e-09 1.0 8.8840e-09 0.0 8.9200e-09 0.0 8.9240e-09 1.0 8.9600e-09 1.0 8.9640e-09 0.0 9.0400e-09 0.0 9.0440e-09 1.0 9.0800e-09 1.0 9.0840e-09 0.0 9.1200e-09 0.0 9.1240e-09 1.0 9.2400e-09 1.0 9.2440e-09 0.0 9.2800e-09 0.0 9.2840e-09 1.0 9.4000e-09 1.0 9.4040e-09 0.0 9.4800e-09 0.0 9.4840e-09 1.0 9.5600e-09 1.0 9.5640e-09 0.0 9.6400e-09 0.0 9.6440e-09 1.0 9.6800e-09 1.0 9.6840e-09 0.0 9.7200e-09 0.0 9.7240e-09 1.0 9.7600e-09 1.0 9.7640e-09 0.0 9.8000e-09 0.0 9.8040e-09 1.0 9.8400e-09 1.0 9.8440e-09 0.0 9.8800e-09 0.0 9.8840e-09 1.0 1.0160e-08 1.0)
* driver output -> cathode (0..2 V reverse bias), anode at 0 V
N0 din kk 0 drv
* laser 1 mW at lambda0 - 50 pm (blue side; reverse bias red-shifts the ring away)
Vin_re in_re 0 1.0
Vin_im in_im 0 0
Vwl wl 0 1549.95
Vh hp 0 0
N1 0 kk hp 0 in_re in_im th_re th_im dr_re dr_im wl tdt mrm

.control
pre_osdi mrm_tcmt.osdi
pre_osdi mrm_driver.osdi
set wr_singlescale
set wr_vecnames
option numdgt=8
tran 0.2p 1.0160e-08 0 0.5p
let pt = v(th_re)^2 + v(th_im)^2
wrdata tran.dat v(din) v(kk) pt v(tdt)
quit
.endc
.end
