// =============================================================================
//  mrm_driver.va  --  Behavioural voltage-mode driver for a micro-ring modulator
// =============================================================================
//
//  din  : logic input (threshold vth, soft decision of width vsharp), or with
//         linear=1 a normalised analog level 0..1 (DAC mode, e.g. PAM4)
//  out  : driver output, Thevenin source with output resistance Rout
//  ref  : output reference (ground / bias rail of the driver)
//
//  Transfer:  v_tgt = vlo + (vhi - vlo) * 0.5*(1 + tanh((V(din)-vth)/vsharp))
//             -> two cascaded real poles (fp each) giving an overall -3 dB
//                bandwidth f3db  (fp = f3db / sqrt(sqrt(2)-1))
//             -> output stage: V(out,ref) = v_filt - Rout * I(out)
//             optional constant pre-emphasis (kemph) implemented as a
//             high-pass boost  v_filt + kemph * tau_e * d(v_filt)/dt,
//             since OpenVAF does not support absdelay()-based FFE.
//
//  Typical use: drive the MRM cathode with vlo..vhi = 0..Vpp while the anode
//  is held at 0 V (reverse bias = depletion-mode operation), or use a DC
//  offset (vlo) to set the bias point.
//
//  Uses only ddt()/tanh(), each ddt in its own contribution: compiles with OpenVAF (ngspice/Xyce OSDI) and
//  commercial Verilog-A simulators.
// =============================================================================

`include "constants.vams"
`include "disciplines.vams"

module mrm_driver(din, out, ref);
    input  din;
    inout  out, ref;
    electrical din, out, ref;
    electrical n1, n2, ne;                   // internal pole nodes, emphasis node

    parameter real vlo    = 0.0    from (-inf:inf);  // V, output for logic 0
    parameter real vhi    = 2.0    from (-inf:inf);  // V, output for logic 1
    parameter real vth    = 0.5    from (-inf:inf);  // V, input threshold
    parameter real vsharp = 0.02   from (0:inf);     // V, decision softness
    parameter real f3db   = 30e9   from (0:inf);     // Hz, overall -3 dB bandwidth
    parameter real Rout   = 50.0   from (0:inf);     // ohm, output resistance
    parameter real kemph  = 0.0    from [0:inf);     // pre-emphasis strength
    parameter real tau_e  = 10e-12 from (0:inf);     // s, emphasis time constant
    parameter integer linear = 0   from [0:1];       // 1: DAC mode, v_tgt = vlo + (vhi-vlo)*V(din) (PAM4)

    real vtgt, tp, vf;

    analog begin
        if (linear == 1)
            vtgt = vlo + (vhi - vlo) * V(din);       // DAC mode: din in 0..1
        else
            vtgt = vlo + (vhi - vlo) * 0.5 * (1.0 + tanh((V(din) - vth) / vsharp));
        tp   = sqrt(sqrt(2.0) - 1.0) / (6.283185307179586 * f3db);

        // two real poles, written as KCL on 1-ohm normalised internal nodes
        // each ddt in a contribution of its own (verilog-a-sim compiled path)
        I(n1) <+ ddt(tp * V(n1));
        I(n1) <+ V(n1) - vtgt;
        I(n2) <+ ddt(tp * V(n2));
        I(n2) <+ V(n2) - V(n1);
        // emphasis node: V(ne) = kemph * tau_e * dV(n2)/dt
        I(ne) <+ V(ne);
        I(ne) <+ -ddt(kemph * tau_e * V(n2));

        vf = V(n2) + V(ne);
        I(out, ref) <+ (V(out, ref) - vf) / Rout;
    end
endmodule
