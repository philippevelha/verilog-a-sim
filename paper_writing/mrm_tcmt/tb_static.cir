* MRM static spectrum vs reverse bias and heater power (ngspice + OSDI)
.model mrm mrm_tcmt mode=0 lambda0=1550 FSR=10 Qi=20000 Qc=22000 eta_mod=20
+ Rs=100 Cj0=20f Vbi=0.8 Mj=0.5 Cpad=10f dlam_dT=75 Rth=5k Cth=1n Rh0=1k
+ f_abs=0.5 self_heat=0

* laser: 1 mW CW (1 V = sqrt(1 mW)), wavelength on 'wl'
Vin_re in_re 0 1.0
Vin_im in_im 0 0
Vwl    wl    0 1550
* junction bias: anode grounded, cathode at +Vr (reverse bias)
Va     a  0 0
Vk     k  0 0
* heater
Vh     hp 0 0
N1 a k hp 0 in_re in_im th_re th_im dr_re dr_im wl tdt mrm

.control
pre_osdi mrm_tcmt.osdi
set wr_singlescale
set wr_vecnames
option numdgt=10
alter Vk dc = 0
dc Vwl 1549.6 1550.6 0.0005
let pt = v(th_re)^2 + v(th_im)^2
wrdata spec_vr0.dat pt
alter Vk dc = 1
dc Vwl 1549.6 1550.6 0.0005
let pt = v(th_re)^2 + v(th_im)^2
wrdata spec_vr1.dat pt
alter Vk dc = 2
dc Vwl 1549.6 1550.6 0.0005
let pt = v(th_re)^2 + v(th_im)^2
wrdata spec_vr2.dat pt
alter Vk dc = 0
alter Vh dc = 0
dc Vwl 1549.6 1550.8 0.0005
let pt = v(th_re)^2 + v(th_im)^2
wrdata spec_vh0.dat pt v(tdt)
alter Vh dc = 1
dc Vwl 1549.6 1550.8 0.0005
let pt = v(th_re)^2 + v(th_im)^2
wrdata spec_vh1.dat pt v(tdt)
alter Vh dc = 0.5
dc Vwl 1549.6 1550.8 0.0005
let pt = v(th_re)^2 + v(th_im)^2
wrdata spec_vh05.dat pt v(tdt)
quit
.endc
.end
