* step test slow_m50
.model drv mrm_driver vlo=0 vhi=2 vth=0.5 f3db=3000000000.0 Rout=50
.model mrm mrm_tcmt mode=0 lambda0=1550 FSR=10 Qi=20000 Qc=22000 eta_mod=20
+ Rs=100 Cj0=20f Vbi=0.8 Mj=0.5 Cpad=10f dlam_dT=75 Rth=5k Cth=1n Rh0=1k f_abs=0.5 self_heat=0
Vd din 0 PWL(0 0 1n 0 1.004n 1 2n 1 2.004n 0 3.5n 0)
N0 din kk 0 drv
Vin_re in_re 0 1.0
Vin_im in_im 0 0
Vwl wl 0 1549.95
Vh hp 0 0
N1 0 kk hp 0 in_re in_im th_re th_im dr_re dr_im wl tdt mrm
.control
pre_osdi mrm_tcmt.osdi
pre_osdi mrm_driver.osdi
set wr_singlescale
set wr_vecnames
option numdgt=12 reltol=1e-6
tran 0.05p 3.5n 0 0.05p

wrdata slow_m50.dat v(kk) v(n1#ai) v(th_re) v(th_im)
quit
.endc
.end
