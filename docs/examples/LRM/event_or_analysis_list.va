// LRM 5.10.1, 5.10.2 — step events with analysis lists, ORed
// Source: OpenVAF-Reloaded PR #35 (https://github.com/OpenVAF/OpenVAF-Reloaded/pull/35),
// which closed this parser gap in OpenVAF. Kept here to check this simulator handles it too.
module event_or_analysis_list(in, out, smpl);
  input in, smpl;
  output out;
  electrical in, out, smpl;
  parameter real thresh = 0.5;
  parameter integer dir = 1;
  parameter real en = 1.0;
  parameter real tau = 1e-6;
  real state, vout;
  analog begin
    @(initial_step("tran") or final_step("tran")) vout = V(in);
    V(out) <+ vout;
  end
endmodule
