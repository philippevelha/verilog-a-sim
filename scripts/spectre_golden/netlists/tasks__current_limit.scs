// tasks__current_limit -- Spectre translation of circuits/tasks/current_limit.net (scripts/spectre_golden/net2spectre.py)
simulator lang=spectre
global 0
opts options reltol=1e-6 vabstol=1e-9 iabstol=1e-15 temp=27 tnom=27 gmin=1e-18 save=selected

ahdl_include "models/tasks/current_limit.va"

V1 (a 0) vsource dc=0
X1 (a 0) current_limit

opts2 options save=lvlpub nestlvl=1
sw dc dev=V1 param=dc start=0 stop=5 step=0.5
