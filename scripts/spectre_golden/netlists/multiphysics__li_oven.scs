// multiphysics__li_oven -- Spectre translation of circuits/multiphysics/li_oven.net (scripts/spectre_golden/net2spectre.py)
simulator lang=spectre
global 0
opts options reltol=1e-6 vabstol=1e-9 iabstol=1e-15 temp=27 tnom=27 gmin=1e-18 save=selected

ahdl_include "models/multiphysics/liion/li_parts.va"

VO1 (o1 0) vsource dc=298.15 type=pwl wave=[ \
    0 298.15 60 403.15 ]
XT1 (th1 o1) cell_thermal
XA1 (th1) abuse
VO2 (o2 0) vsource dc=298.15 type=pwl wave=[ \
    0 298.15 60 408.15 ]
XT2 (th2 o2) cell_thermal
XA2 (th2) abuse
VO3 (o3 0) vsource dc=298.15 type=pwl wave=[ \
    0 298.15 60 413.15 ]
XT3 (th3 o3) cell_thermal
XA3 (th3) abuse

save th1 th2 th3
tr tran stop=36000 step=10
