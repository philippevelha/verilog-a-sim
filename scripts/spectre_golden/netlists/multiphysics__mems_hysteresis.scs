// multiphysics__mems_hysteresis -- Spectre translation of circuits/multiphysics/mems_hysteresis.net (scripts/spectre_golden/net2spectre.py)
simulator lang=spectre
global 0
opts options reltol=1e-6 vabstol=1e-9 iabstol=1e-15 temp=27 tnom=27 gmin=1e-18 save=selected

ahdl_include "models/multiphysics/mems/mems_parts.va"

V1 (drv 0) vsource dc=0 type=pwl wave=[ \
    0 0 0.005 7 0.01 0 ]
XE (drv 0 x) es_gap area=1e-08 g0=2e-06 td=1e-07 er=7.5
XK (x) spring k=1
XM (x) proof_mass m=2.53e-10
XS (x) squeeze_film pressure=100
XT (x) thermoelastic
XC (x drv 0) contact xc=1.9e-06 kc=1000000000 fa=2e-07 delta=2e-10

save x
tr tran stop=0.01 step=2e-06
