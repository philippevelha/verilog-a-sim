// multiphysics__speaker_ac -- Spectre translation of circuits/multiphysics/speaker_ac.net (scripts/spectre_golden/net2spectre.py)
simulator lang=spectre
global 0
opts options reltol=1e-6 vabstol=1e-9 iabstol=1e-15 temp=27 tnom=27 gmin=1e-18 save=selected

ahdl_include "models/multiphysics/speaker/speaker_parts.va"

V1 (p1 0) vsource dc=0 mag=2.83 phase=0
V2 (p2 0) vsource dc=0 mag=2.83 phase=0
VA (amb 0) vsource dc=293.15
X1 (p1 0 t1 th1) driver
XC1 (t1) chamber
XH1 (t1 m1) horn N=64
XM1 (m1) mouth
XT1 (th1 amb) vc_thermal
X2 (p2 0 t2 th2) driver
XC2 (t2) chamber
XH2 (t2 m2) horn N=256
XM2 (m2) mouth
XT2 (th2 amb) vc_thermal

save V1:p V2:p m1 m2
ac1 ac start=10 stop=1000 dec=40
