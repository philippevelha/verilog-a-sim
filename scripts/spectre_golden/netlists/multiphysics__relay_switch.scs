// multiphysics__relay_switch -- Spectre translation of circuits/multiphysics/relay_switch.net (scripts/spectre_golden/net2spectre.py)
simulator lang=spectre
global 0
opts options reltol=1e-6 vabstol=1e-9 iabstol=1e-15 temp=27 tnom=27 gmin=1e-18 save=selected

ahdl_include "models/multiphysics/relay/relay_parts.va"

VA20 (a20 0) vsource dc=293.15
VA85 (a85 0) vsource dc=358.15
VC (c 0) vsource dc=0 type=pwl wave=[ \
    0 0 1 30 1.5 30 2.5 0 3 0 ]
X1 (c 0 x1 th1) relay_coil
XA1 (x1 c) armature xmax=0.0008
XT1 (th1 a20) coil_thermal
X2 (c 0 x2 th2) relay_coil
XA2 (x2 c) armature xmax=0.0008
XT2 (th2 a85) coil_thermal
X3 (c 0 x3 th3) relay_coil
XA3 (x3 c) armature xmax=0.00098
XT3 (th3 a20) coil_thermal

save x1 x2 x3 c
tr tran stop=3 step=0.0001
