// fundamental_diagram -- Spectre translation of circuits/fundamental_diagram.net (scripts/spectre_golden/net2spectre.py)
simulator lang=spectre
global 0
opts options reltol=1e-6 vabstol=1e-9 iabstol=1e-15 temp=27 tnom=27 gmin=1e-18 save=selected

ahdl_include "models/fundamental_diagram.va"

Vc (c 0) vsource dc=0
X1 (c q v) fundamental_diagram

opts2 options save=lvlpub nestlvl=1
sw dc dev=Vc param=dc start=0 stop=180 step=2
