// multiphysics__piezo_storage -- Spectre translation of circuits/multiphysics/piezo_storage.net (scripts/spectre_golden/net2spectre.py)
simulator lang=spectre
global 0
opts options reltol=1e-6 vabstol=1e-9 iabstol=1e-15 temp=27 tnom=27 gmin=1e-18 save=selected

ahdl_include "models/multiphysics/piezo/piezo_parts.va"

XM0 (a0) multisine arms=4 f0=30 f1=80 seed=0
XBL0 (a0 pL0 nL0) piezo_beam
D1L0 (pL0 sL0) schottky
D2L0 (nL0 sL0) schottky
D3L0 (0 pL0) schottky
D4L0 (0 nL0) schottky
CL0 (sL0 0) capacitor c=2.2e-05
RL0 (sL0 0) resistor r=1000000
XBH0 (a0 pH0 nH0) piezo_beam k3=200000000
D1H0 (pH0 sH0) schottky
D2H0 (nH0 sH0) schottky
D3H0 (0 pH0) schottky
D4H0 (0 nH0) schottky
CH0 (sH0 0) capacitor c=2.2e-05
RH0 (sH0 0) resistor r=1000000
XM1 (a1) multisine arms=4 f0=30 f1=80 seed=1
XBL1 (a1 pL1 nL1) piezo_beam
D1L1 (pL1 sL1) schottky
D2L1 (nL1 sL1) schottky
D3L1 (0 pL1) schottky
D4L1 (0 nL1) schottky
CL1 (sL1 0) capacitor c=2.2e-05
RL1 (sL1 0) resistor r=1000000
XBH1 (a1 pH1 nH1) piezo_beam k3=200000000
D1H1 (pH1 sH1) schottky
D2H1 (nH1 sH1) schottky
D3H1 (0 pH1) schottky
D4H1 (0 nH1) schottky
CH1 (sH1 0) capacitor c=2.2e-05
RH1 (sH1 0) resistor r=1000000
XM2 (a2) multisine arms=4 f0=30 f1=80 seed=2
XBL2 (a2 pL2 nL2) piezo_beam
D1L2 (pL2 sL2) schottky
D2L2 (nL2 sL2) schottky
D3L2 (0 pL2) schottky
D4L2 (0 nL2) schottky
CL2 (sL2 0) capacitor c=2.2e-05
RL2 (sL2 0) resistor r=1000000
XBH2 (a2 pH2 nH2) piezo_beam k3=200000000
D1H2 (pH2 sH2) schottky
D2H2 (nH2 sH2) schottky
D3H2 (0 pH2) schottky
D4H2 (0 nH2) schottky
CH2 (sH2 0) capacitor c=2.2e-05
RH2 (sH2 0) resistor r=1000000
XM3 (a3) multisine arms=4 f0=30 f1=80 seed=3
XBL3 (a3 pL3 nL3) piezo_beam
D1L3 (pL3 sL3) schottky
D2L3 (nL3 sL3) schottky
D3L3 (0 pL3) schottky
D4L3 (0 nL3) schottky
CL3 (sL3 0) capacitor c=2.2e-05
RL3 (sL3 0) resistor r=1000000
XBH3 (a3 pH3 nH3) piezo_beam k3=200000000
D1H3 (pH3 sH3) schottky
D2H3 (nH3 sH3) schottky
D3H3 (0 pH3) schottky
D4H3 (0 nH3) schottky
CH3 (sH3 0) capacitor c=2.2e-05
RH3 (sH3 0) resistor r=1000000

save sL0 sH0 sL1 sH1 sL2 sH2 sL3 sH3
tr tran stop=10 step=0.0001
