// benchmark__psp103_inverter_vtc -- Spectre translation of circuits/benchmark/psp103_inverter_vtc.net (scripts/spectre_golden/net2spectre.py)
simulator lang=spectre
global 0
opts options reltol=1e-6 vabstol=1e-9 iabstol=1e-15 temp=27 tnom=27 gmin=1e-18 save=selected

ahdl_include "benchmark/models/psp103/psp103.va"

Vdd (vdd 0) vsource dc=1.2
Vmeas (vss 0) vsource dc=0
V1 (in 0) vsource dc=0
model XMP_model PSP103VA TYPE=-1
XMP (out in vdd vdd) XMP_model L=1e-07 W=1e-06
model XMN_model PSP103VA TYPE=1
XMN (out in vss vss) XMN_model L=1e-07 W=1e-06
C3 (in vss) capacitor c=3.84e-16
C2 (out vss) capacitor c=5.76e-16

save out Vmeas:p
sw dc dev=V1 param=dc start=0 stop=1.2 step=0.012
