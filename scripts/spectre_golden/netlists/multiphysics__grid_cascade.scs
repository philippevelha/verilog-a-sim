// multiphysics__grid_cascade -- Spectre translation of circuits/multiphysics/grid_cascade.net (scripts/spectre_golden/net2spectre.py)
simulator lang=spectre
global 0
opts options reltol=1e-6 vabstol=1e-9 iabstol=1e-15 temp=27 tnom=27 gmin=1e-18 save=selected

ahdl_include "models/multiphysics/powergrid/grid_parts.va"

XA1 (a1) machine pm=0.9 h=5 d=0.1 eps=1e-06
XA2 (a2) machine pm=0.9 h=5 d=0.1 eps=1e-06
XA3 (a3) machine pm=0.9 h=5 d=0.1 eps=1e-06
XA4 (a4) machine pm=0.9 h=5 d=0.1 eps=1e-06
XLA12 (a1 a2) line bmax=10
XLA23 (a2 a3) line bmax=10
XLA34 (a3 a4) line bmax=10
XLA41 (a4 a1) line bmax=10
XB1 (b1) machine pm=-0.9 h=5 d=0.1 eps=1e-06
XB2 (b2) machine pm=-0.9 h=5 d=0.1 eps=1e-06
XB3 (b3) machine pm=-0.9 h=5 d=0.1 eps=1e-06
XB4 (b4) machine pm=-0.9 h=5 d=0.1 eps=1e-06
XLB12 (b1 b2) line bmax=10
XLB23 (b2 b3) line bmax=10
XLB34 (b3 b4) line bmax=10
XLB41 (b4 b1) line bmax=10
XT1 (a1 b1) line bmax=2.5 pmax=1.6
XT2 (a2 b2) line bmax=2 pmax=1.6
XT3 (a3 b3) line bmax=1.5 pmax=1.6 t_open=1

save XA1.w XB1.w
tr tran stop=10 step=0.001
