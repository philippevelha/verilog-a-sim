// snn__transistor__xbar_h2_16 -- Spectre translation of circuits/snn/transistor/xbar_h2_16.net (scripts/spectre_golden/net2spectre.py)
simulator lang=spectre
global 0
opts options reltol=1e-6 vabstol=1e-9 iabstol=1e-15 temp=27 tnom=27 gmin=1e-18 save=selected

ahdl_include "models/sg13g2/psp103/psp103.va"
ahdl_include "models/snn/rram.va"
ahdl_include "models/snn/vswitch.va"
ahdl_include "models/snn/sl_stage.va"
ahdl_include "models/snn/comparator.va"
ahdl_include "models/snn/neuron_logic.va"

model hvn_w10000n_l450n_ng1 PSP103VA TYPE=1 TR=27 DTA=0 SWGEO=1 SWIGATE=1 SWIMPACT=1 SWGIDL=0 SWJUNCAP=3 SWJUNASYM=0 SWNUD=0 SWEDGE=0 SWDELVTAC=0 SWIGN=1 QMC=1 LVARO=3.499e-08 LVARL=-0.09125 LVARW=0 LAP=6.3866e-08 WVARO=0 WVARL=0 WVARW=0 WOT=3e-08 DLQ=5.2202e-08 DWQ=3e-08 VFBO=-0.89839 VFBL=0.15096 VFBW=0.0017033 VFBLW=0.019398 STVFBO=0.0008739 STVFBL=0.00014864 STVFBW=-4.6174e-05 STVFBLW=-2.445e-06 ST2VFBO=0 TOXO=7.4256e-09 EPSROXO=3.9 NSUBO=1.8552e+23 NSUBW=-0.0050198 WSEG=1.098e-10 NPCK=3.178e+23 NPCKW=-2.7604 WSEGP=1e-08 LPCK=1e-08 LPCKW=0 FOL1=0.21033 FOL2=0.0026472 FACNEFFACO=1 FACNEFFACL=0 FACNEFFACW=0 FACNEFFACLW=0 GFACNUDO=1 GFACNUDL=0 GFACNUDLEXP=1 GFACNUDW=0 GFACNUDLW=0 VSBNUDO=0 DVSBNUDO=1 VNSUBO=0 NSLPO=0.05 DNSUBO=0.025686 DPHIBO=-0.0607576464 DPHIBL=-0.00546403785 DPHIBLEXP=2.3956 DPHIBW=0.014614 DPHIBLW=-0.017476272 DELVTACO=0 DELVTACL=0 DELVTACLEXP=1 DELVTACW=0 DELVTACLW=0 NPO=3.897e+26 NPL=-0.1215 TOXOVO=7.4256e-09 TOXOVDO=2e-09 LOV=6.3866e-08 LOVD=0 NOVO=5.5814e+24 NOVDO=5e+25 CTO=-0.061658 CTL=0.025 CTLEXP=1.6063 CTW=-0.044911 CTLW=-0.0077386 CTGO=0 CTBO=0 STCTO=1 CFL=0.0048288 CFLEXP=1.3328 CFW=0.037319 CFBO=0.26069 CFDO=0 PSCEL=0 PSCELEXP=2 PSCEW=0 PSCEBO=0 PSCEDO=0 UO=0.046687 FBET1=-0.35712 FBET1W=-0.14995 LP1=4.5615e-08 LP1W=0.4189 FBET2=-1.0245 LP2=9.42e-09 BETW1=0.6567 BETW2=-0.083639 WBET=1.0063e-10 STBETO=1.6942 STBETL=-0.0065587 STBETW=-0.060053 STBETLW=0.00036994 MUEO=0.91692524 MUEW=-0.018226 STMUEO=0.34067 THEMUO=2.5509 STTHEMUO=0.63756 CSO=2.0494 CSL=-0.97261 CSLEXP=0 CSW=0.044205 CSLW=-1.0021 STCSO=2.5545 THECSO=2 STTHECSO=0 XCORO=0.04872 XCORL=-0.27137 XCORW=-0.1948 XCORLW=0 STXCORO=1.1327 FETAO=1.0706 RSW1=321.598966 RSW2=-0.07 STRSO=-0.058157 RSBO=-0.0025425 RSGO=0.10986 THESATO=0.1 THESATL=0.446499 THESATLEXP=1.0973 THESATW=0.082797 THESATLW=-0.032897685 STTHESATO=0.48396 STTHESATL=0.50226 STTHESATW=0.049985 STTHESATLW=-0.059487 THESATBO=0.06 THESATGO=0.050814 AXO=8.7694 AXL=2.3029 ALPL=0.0019702 ALPLEXP=1.4003 ALPW=1.1052 ALP1L1=0.007475 ALP1LEXP=0.80983 ALP1L2=0.719 ALP1W=0.56703 ALP2L1=5.413e-07 ALP2LEXP=0.2541 ALP2L2=0 ALP2W=-10 VPO=0.06567 A1O=4.7288 A1L=0.052459 A1W=0.024056 A2O=22.013 STA2O=0.018532 A3O=1.2047 A3L=-0.10308 A3W=0.0069117 A4O=0.12894 A4L=-0.05413 A4W=-0.06197 GCOO=0 IGINVLW=0 IGOVW=0 IGOVDW=0 STIGO=2 GC2O=0.375 GC3O=0.063 CHIBO=3.1 AGIDLW=70 AGIDLDW=0 BGIDLO=13 BGIDLDO=41 STBGIDLO=-0.001067 STBGIDLDO=0 CGIDLO=0 CGIDLDO=0 CGBOVL=2.522e-16 CFRDW=0 FNTO=1 FNTEXCL=0 NFALW=1.42e+25 NFBLW=574300000 NFCLW=-3.015e-08 EFO=1 LINTNOI=-3.158e-08 ALPNOI=2.708 WEDGE=1e-08 WEDGEW=0 VFBEDGEO=-1 STVFBEDGEO=0.0005 STVFBEDGEL=0 STVFBEDGEW=0 STVFBEDGELW=0 DPHIBEDGEO=0 DPHIBEDGEL=0 DPHIBEDGELEXP=1 DPHIBEDGEW=0 DPHIBEDGELW=0 NSUBEDGEO=5e+23 NSUBEDGEL=0 NSUBEDGELEXP=1 NSUBEDGEW=0 NSUBEDGELW=0 CTEDGEO=0 CTEDGEL=0 CTEDGELEXP=1 FBETEDGE=0 LPEDGE=1e-08 BETEDGEW=0 STBETEDGEO=1 STBETEDGEL=0 STBETEDGEW=0 STBETEDGELW=0 PSCEEDGEL=0 PSCEEDGELEXP=2 PSCEEDGEW=0 PSCEBEDGEO=0 PSCEDEDGEO=0 CFEDGEL=0 CFEDGELEXP=2 CFEDGEW=0 CFDEDGEO=0 CFBEDGEO=0 FNTEDGEO=1 NFAEDGELW=8e+22 NFBEDGELW=30000000 NFCEDGELW=0 EFEDGEO=1 SAREF=1e-06 SBREF=1e-06 WLOD=0 KUO=0 KVSAT=0 TKUO=0 LKUO=0 WKUO=0 PKUO=0 LLODKUO=0 WLODKUO=0 KVTHO=0 LKVTHO=0 WKVTHO=0 PKVTHO=0 LLODVTH=0 WLODVTH=0 STETAO=0 LODETAO=1 SCREF=1e-06 WEB=0 WEC=0 KVTHOWEO=0 KVTHOWEL=0 KVTHOWEW=0 KVTHOWELW=0 KUOWEO=0 KUOWEL=0 KUOWEW=0 KUOWELW=0 TRJ=21 SWJUNEXP=0 IMAX=0.0020128 FREV=1000 CJORBOT=0.00085856 CJORSTI=2.4557e-11 CJORGAT=1.3846e-11 VBIRBOT=0.74373 VBIRSTI=1.597 VBIRGAT=0.6629 PBOT=0.27424 PSTI=0.16571 PGAT=0.1451 CJORBOTD=0.001 CJORSTID=1e-09 CJORGATD=1e-09 VBIRBOTD=1 VBIRSTID=1 VBIRGATD=1 PBOTD=0.5 PSTID=0.5 PGATD=0.5 PHIGBOT=1.1984 PHIGSTI=1.006 PHIGGAT=0.3 IDSATRBOT=5.397e-08 IDSATRSTI=4.0612e-15 IDSATRGAT=0 CSRHBOT=100 CSRHSTI=0.0001 CSRHGAT=0.0001 XJUNSTI=1.61e-08 XJUNGAT=6.134e-07 PHIGBOTD=1.16 PHIGSTID=1.16 PHIGGATD=1.16 IDSATRBOTD=1e-12 IDSATRSTID=1e-18 IDSATRGATD=1e-18 CSRHBOTD=100 CSRHSTID=0.0001 CSRHGATD=0.0001 XJUNSTID=1e-07 XJUNGATD=1e-07 CTATBOT=100 CTATSTI=0.0001 CTATGAT=0.0001 MEFFTATBOT=0.25 MEFFTATSTI=0.25 MEFFTATGAT=0.25 CTATBOTD=100 CTATSTID=0.0001 CTATGATD=0.0001 MEFFTATBOTD=0.25 MEFFTATSTID=0.25 MEFFTATGATD=0.25 CBBTBOT=1e-12 CBBTSTI=1e-21 CBBTGAT=1e-18 FBBTRBOT=1000000000 FBBTRSTI=1000000000 FBBTRGAT=1000000000 STFBBTBOT=-0.001 STFBBTSTI=-0.001 STFBBTGAT=-0.001 CBBTBOTD=1e-12 CBBTSTID=1e-18 CBBTGATD=1e-18 FBBTRBOTD=1000000000 FBBTRSTID=1000000000 FBBTRGATD=1000000000 STFBBTBOTD=-0.001 STFBBTSTID=-0.001 STFBBTGATD=-0.001 VBRBOT=10 VBRSTI=10 VBRGAT=10 PBRBOT=4 PBRSTI=4 PBRGAT=4 VBRBOTD=10 VBRSTID=10 VBRGATD=10 PBRBOTD=4 PBRSTID=4 PBRGATD=4 VJUNREF=2.5 FJUNQ=0.03 VJUNREFD=2.5 FJUNQD=0.03 RINT=3.0856e-12 RVPOLY=0 DLSIL=0 RSH=0 RSHD=0 CFRW=1.2e-16 RSHG=20 RGO=35 RBULKO=200 RWELLO=200 RJUNSO=225 RJUNDO=225 SWSOA=0 VGS_MAX=3 VGD_MAX=3 VGB_MAX=3 VDS_MAX=3 VDB_MAX=1.6 VSB_MAX=1.6
model hvn_w1000n_l450n_ng1 PSP103VA TYPE=1 TR=27 DTA=0 SWGEO=1 SWIGATE=1 SWIMPACT=1 SWGIDL=0 SWJUNCAP=3 SWJUNASYM=0 SWNUD=0 SWEDGE=0 SWDELVTAC=0 SWIGN=1 QMC=1 LVARO=3.499e-08 LVARL=-0.09125 LVARW=0 LAP=6.3866e-08 WVARO=0 WVARL=0 WVARW=0 WOT=3e-08 DLQ=5.2202e-08 DWQ=3e-08 VFBO=-0.89839 VFBL=0.15096 VFBW=0.0017033 VFBLW=0.019398 STVFBO=0.0008739 STVFBL=0.00014864 STVFBW=-4.6174e-05 STVFBLW=-2.445e-06 ST2VFBO=0 TOXO=7.4256e-09 EPSROXO=3.9 NSUBO=1.8552e+23 NSUBW=-0.0050198 WSEG=1.098e-10 NPCK=3.178e+23 NPCKW=-2.7604 WSEGP=1e-08 LPCK=1e-08 LPCKW=0 FOL1=0.21033 FOL2=0.0026472 FACNEFFACO=1 FACNEFFACL=0 FACNEFFACW=0 FACNEFFACLW=0 GFACNUDO=1 GFACNUDL=0 GFACNUDLEXP=1 GFACNUDW=0 GFACNUDLW=0 VSBNUDO=0 DVSBNUDO=1 VNSUBO=0 NSLPO=0.05 DNSUBO=0.025686 DPHIBO=-0.0607576464 DPHIBL=-0.00546403785 DPHIBLEXP=2.3956 DPHIBW=0.014614 DPHIBLW=-0.017476272 DELVTACO=0 DELVTACL=0 DELVTACLEXP=1 DELVTACW=0 DELVTACLW=0 NPO=3.897e+26 NPL=-0.1215 TOXOVO=7.4256e-09 TOXOVDO=2e-09 LOV=6.3866e-08 LOVD=0 NOVO=5.5814e+24 NOVDO=5e+25 CTO=-0.061658 CTL=0.025 CTLEXP=1.6063 CTW=-0.044911 CTLW=-0.0077386 CTGO=0 CTBO=0 STCTO=1 CFL=0.0048288 CFLEXP=1.3328 CFW=0.037319 CFBO=0.26069 CFDO=0 PSCEL=0 PSCELEXP=2 PSCEW=0 PSCEBO=0 PSCEDO=0 UO=0.046687 FBET1=-0.35712 FBET1W=-0.14995 LP1=4.5615e-08 LP1W=0.4189 FBET2=-1.0245 LP2=9.42e-09 BETW1=0.6567 BETW2=-0.083639 WBET=1.0063e-10 STBETO=1.6942 STBETL=-0.0065587 STBETW=-0.060053 STBETLW=0.00036994 MUEO=0.91692524 MUEW=-0.018226 STMUEO=0.34067 THEMUO=2.5509 STTHEMUO=0.63756 CSO=2.0494 CSL=-0.97261 CSLEXP=0 CSW=0.044205 CSLW=-1.0021 STCSO=2.5545 THECSO=2 STTHECSO=0 XCORO=0.04872 XCORL=-0.27137 XCORW=-0.1948 XCORLW=0 STXCORO=1.1327 FETAO=1.0706 RSW1=321.598966 RSW2=-0.07 STRSO=-0.058157 RSBO=-0.0025425 RSGO=0.10986 THESATO=0.1 THESATL=0.446499 THESATLEXP=1.0973 THESATW=0.082797 THESATLW=-0.032897685 STTHESATO=0.48396 STTHESATL=0.50226 STTHESATW=0.049985 STTHESATLW=-0.059487 THESATBO=0.06 THESATGO=0.050814 AXO=8.7694 AXL=2.3029 ALPL=0.0019702 ALPLEXP=1.4003 ALPW=1.1052 ALP1L1=0.007475 ALP1LEXP=0.80983 ALP1L2=0.719 ALP1W=0.56703 ALP2L1=5.413e-07 ALP2LEXP=0.2541 ALP2L2=0 ALP2W=-10 VPO=0.06567 A1O=4.7288 A1L=0.052459 A1W=0.024056 A2O=22.013 STA2O=0.018532 A3O=1.2047 A3L=-0.10308 A3W=0.0069117 A4O=0.12894 A4L=-0.05413 A4W=-0.06197 GCOO=0 IGINVLW=0 IGOVW=0 IGOVDW=0 STIGO=2 GC2O=0.375 GC3O=0.063 CHIBO=3.1 AGIDLW=70 AGIDLDW=0 BGIDLO=13 BGIDLDO=41 STBGIDLO=-0.001067 STBGIDLDO=0 CGIDLO=0 CGIDLDO=0 CGBOVL=2.522e-16 CFRDW=0 FNTO=1 FNTEXCL=0 NFALW=1.42e+25 NFBLW=574300000 NFCLW=-3.015e-08 EFO=1 LINTNOI=-3.158e-08 ALPNOI=2.708 WEDGE=1e-08 WEDGEW=0 VFBEDGEO=-1 STVFBEDGEO=0.0005 STVFBEDGEL=0 STVFBEDGEW=0 STVFBEDGELW=0 DPHIBEDGEO=0 DPHIBEDGEL=0 DPHIBEDGELEXP=1 DPHIBEDGEW=0 DPHIBEDGELW=0 NSUBEDGEO=5e+23 NSUBEDGEL=0 NSUBEDGELEXP=1 NSUBEDGEW=0 NSUBEDGELW=0 CTEDGEO=0 CTEDGEL=0 CTEDGELEXP=1 FBETEDGE=0 LPEDGE=1e-08 BETEDGEW=0 STBETEDGEO=1 STBETEDGEL=0 STBETEDGEW=0 STBETEDGELW=0 PSCEEDGEL=0 PSCEEDGELEXP=2 PSCEEDGEW=0 PSCEBEDGEO=0 PSCEDEDGEO=0 CFEDGEL=0 CFEDGELEXP=2 CFEDGEW=0 CFDEDGEO=0 CFBEDGEO=0 FNTEDGEO=1 NFAEDGELW=8e+22 NFBEDGELW=30000000 NFCEDGELW=0 EFEDGEO=1 SAREF=1e-06 SBREF=1e-06 WLOD=0 KUO=0 KVSAT=0 TKUO=0 LKUO=0 WKUO=0 PKUO=0 LLODKUO=0 WLODKUO=0 KVTHO=0 LKVTHO=0 WKVTHO=0 PKVTHO=0 LLODVTH=0 WLODVTH=0 STETAO=0 LODETAO=1 SCREF=1e-06 WEB=0 WEC=0 KVTHOWEO=0 KVTHOWEL=0 KVTHOWEW=0 KVTHOWELW=0 KUOWEO=0 KUOWEL=0 KUOWEW=0 KUOWELW=0 TRJ=21 SWJUNEXP=0 IMAX=0.0020128 FREV=1000 CJORBOT=0.00085856 CJORSTI=2.4557e-11 CJORGAT=1.3846e-11 VBIRBOT=0.74373 VBIRSTI=1.597 VBIRGAT=0.6629 PBOT=0.27424 PSTI=0.16571 PGAT=0.1451 CJORBOTD=0.001 CJORSTID=1e-09 CJORGATD=1e-09 VBIRBOTD=1 VBIRSTID=1 VBIRGATD=1 PBOTD=0.5 PSTID=0.5 PGATD=0.5 PHIGBOT=1.1984 PHIGSTI=1.006 PHIGGAT=0.3 IDSATRBOT=5.397e-08 IDSATRSTI=4.0612e-15 IDSATRGAT=0 CSRHBOT=100 CSRHSTI=0.0001 CSRHGAT=0.0001 XJUNSTI=1.61e-08 XJUNGAT=6.134e-07 PHIGBOTD=1.16 PHIGSTID=1.16 PHIGGATD=1.16 IDSATRBOTD=1e-12 IDSATRSTID=1e-18 IDSATRGATD=1e-18 CSRHBOTD=100 CSRHSTID=0.0001 CSRHGATD=0.0001 XJUNSTID=1e-07 XJUNGATD=1e-07 CTATBOT=100 CTATSTI=0.0001 CTATGAT=0.0001 MEFFTATBOT=0.25 MEFFTATSTI=0.25 MEFFTATGAT=0.25 CTATBOTD=100 CTATSTID=0.0001 CTATGATD=0.0001 MEFFTATBOTD=0.25 MEFFTATSTID=0.25 MEFFTATGATD=0.25 CBBTBOT=1e-12 CBBTSTI=1e-21 CBBTGAT=1e-18 FBBTRBOT=1000000000 FBBTRSTI=1000000000 FBBTRGAT=1000000000 STFBBTBOT=-0.001 STFBBTSTI=-0.001 STFBBTGAT=-0.001 CBBTBOTD=1e-12 CBBTSTID=1e-18 CBBTGATD=1e-18 FBBTRBOTD=1000000000 FBBTRSTID=1000000000 FBBTRGATD=1000000000 STFBBTBOTD=-0.001 STFBBTSTID=-0.001 STFBBTGATD=-0.001 VBRBOT=10 VBRSTI=10 VBRGAT=10 PBRBOT=4 PBRSTI=4 PBRGAT=4 VBRBOTD=10 VBRSTID=10 VBRGATD=10 PBRBOTD=4 PBRSTID=4 PBRGATD=4 VJUNREF=2.5 FJUNQ=0.03 VJUNREFD=2.5 FJUNQD=0.03 RINT=3.0856e-12 RVPOLY=0 DLSIL=0 RSH=0 RSHD=0 CFRW=1.2e-16 RSHG=20 RGO=35 RBULKO=2000 RWELLO=2000 RJUNSO=2250 RJUNDO=2250 SWSOA=0 VGS_MAX=3 VGD_MAX=3 VGB_MAX=3 VDS_MAX=3 VDB_MAX=1.6 VSB_MAX=1.6
model hvn_w10338n_l2000n_ng2 PSP103VA TYPE=1 TR=27 DTA=0 SWGEO=1 SWIGATE=1 SWIMPACT=1 SWGIDL=0 SWJUNCAP=3 SWJUNASYM=0 SWNUD=0 SWEDGE=0 SWDELVTAC=0 SWIGN=1 QMC=1 LVARO=3.499e-08 LVARL=-0.09125 LVARW=0 LAP=6.3866e-08 WVARO=0 WVARL=0 WVARW=0 WOT=3e-08 DLQ=5.2202e-08 DWQ=3e-08 VFBO=-0.89839 VFBL=0.15096 VFBW=0.0017033 VFBLW=0.019398 STVFBO=0.0008739 STVFBL=0.00014864 STVFBW=-4.6174e-05 STVFBLW=-2.445e-06 ST2VFBO=0 TOXO=7.4256e-09 EPSROXO=3.9 NSUBO=1.8552e+23 NSUBW=-0.0050198 WSEG=1.098e-10 NPCK=3.178e+23 NPCKW=-2.7604 WSEGP=1e-08 LPCK=1e-08 LPCKW=0 FOL1=0.21033 FOL2=0.0026472 FACNEFFACO=1 FACNEFFACL=0 FACNEFFACW=0 FACNEFFACLW=0 GFACNUDO=1 GFACNUDL=0 GFACNUDLEXP=1 GFACNUDW=0 GFACNUDLW=0 VSBNUDO=0 DVSBNUDO=1 VNSUBO=0 NSLPO=0.05 DNSUBO=0.025686 DPHIBO=-0.0607576464 DPHIBL=-0.00546403785 DPHIBLEXP=2.3956 DPHIBW=0.014614 DPHIBLW=-0.017476272 DELVTACO=0 DELVTACL=0 DELVTACLEXP=1 DELVTACW=0 DELVTACLW=0 NPO=3.897e+26 NPL=-0.1215 TOXOVO=7.4256e-09 TOXOVDO=2e-09 LOV=6.3866e-08 LOVD=0 NOVO=5.5814e+24 NOVDO=5e+25 CTO=-0.061658 CTL=0.025 CTLEXP=1.6063 CTW=-0.044911 CTLW=-0.0077386 CTGO=0 CTBO=0 STCTO=1 CFL=0.0048288 CFLEXP=1.3328 CFW=0.037319 CFBO=0.26069 CFDO=0 PSCEL=0 PSCELEXP=2 PSCEW=0 PSCEBO=0 PSCEDO=0 UO=0.046687 FBET1=-0.35712 FBET1W=-0.14995 LP1=4.5615e-08 LP1W=0.4189 FBET2=-1.0245 LP2=9.42e-09 BETW1=0.6567 BETW2=-0.083639 WBET=1.0063e-10 STBETO=1.6942 STBETL=-0.0065587 STBETW=-0.060053 STBETLW=0.00036994 MUEO=0.91692524 MUEW=-0.018226 STMUEO=0.34067 THEMUO=2.5509 STTHEMUO=0.63756 CSO=2.0494 CSL=-0.97261 CSLEXP=0 CSW=0.044205 CSLW=-1.0021 STCSO=2.5545 THECSO=2 STTHECSO=0 XCORO=0.04872 XCORL=-0.27137 XCORW=-0.1948 XCORLW=0 STXCORO=1.1327 FETAO=1.0706 RSW1=321.598966 RSW2=-0.07 STRSO=-0.058157 RSBO=-0.0025425 RSGO=0.10986 THESATO=0.1 THESATL=0.446499 THESATLEXP=1.0973 THESATW=0.082797 THESATLW=-0.032897685 STTHESATO=0.48396 STTHESATL=0.50226 STTHESATW=0.049985 STTHESATLW=-0.059487 THESATBO=0.06 THESATGO=0.050814 AXO=8.7694 AXL=2.3029 ALPL=0.0019702 ALPLEXP=1.4003 ALPW=1.1052 ALP1L1=0.007475 ALP1LEXP=0.80983 ALP1L2=0.719 ALP1W=0.56703 ALP2L1=5.413e-07 ALP2LEXP=0.2541 ALP2L2=0 ALP2W=-10 VPO=0.06567 A1O=4.7288 A1L=0.052459 A1W=0.024056 A2O=22.013 STA2O=0.018532 A3O=1.2047 A3L=-0.10308 A3W=0.0069117 A4O=0.12894 A4L=-0.05413 A4W=-0.06197 GCOO=0 IGINVLW=0 IGOVW=0 IGOVDW=0 STIGO=2 GC2O=0.375 GC3O=0.063 CHIBO=3.1 AGIDLW=70 AGIDLDW=0 BGIDLO=13 BGIDLDO=41 STBGIDLO=-0.001067 STBGIDLDO=0 CGIDLO=0 CGIDLDO=0 CGBOVL=2.522e-16 CFRDW=0 FNTO=1 FNTEXCL=0 NFALW=1.42e+25 NFBLW=574300000 NFCLW=-3.015e-08 EFO=1 LINTNOI=-3.158e-08 ALPNOI=2.708 WEDGE=1e-08 WEDGEW=0 VFBEDGEO=-1 STVFBEDGEO=0.0005 STVFBEDGEL=0 STVFBEDGEW=0 STVFBEDGELW=0 DPHIBEDGEO=0 DPHIBEDGEL=0 DPHIBEDGELEXP=1 DPHIBEDGEW=0 DPHIBEDGELW=0 NSUBEDGEO=5e+23 NSUBEDGEL=0 NSUBEDGELEXP=1 NSUBEDGEW=0 NSUBEDGELW=0 CTEDGEO=0 CTEDGEL=0 CTEDGELEXP=1 FBETEDGE=0 LPEDGE=1e-08 BETEDGEW=0 STBETEDGEO=1 STBETEDGEL=0 STBETEDGEW=0 STBETEDGELW=0 PSCEEDGEL=0 PSCEEDGELEXP=2 PSCEEDGEW=0 PSCEBEDGEO=0 PSCEDEDGEO=0 CFEDGEL=0 CFEDGELEXP=2 CFEDGEW=0 CFDEDGEO=0 CFBEDGEO=0 FNTEDGEO=1 NFAEDGELW=8e+22 NFBEDGELW=30000000 NFCEDGELW=0 EFEDGEO=1 SAREF=1e-06 SBREF=1e-06 WLOD=0 KUO=0 KVSAT=0 TKUO=0 LKUO=0 WKUO=0 PKUO=0 LLODKUO=0 WLODKUO=0 KVTHO=0 LKVTHO=0 WKVTHO=0 PKVTHO=0 LLODVTH=0 WLODVTH=0 STETAO=0 LODETAO=1 SCREF=1e-06 WEB=0 WEC=0 KVTHOWEO=0 KVTHOWEL=0 KVTHOWEW=0 KVTHOWELW=0 KUOWEO=0 KUOWEL=0 KUOWEW=0 KUOWELW=0 TRJ=21 SWJUNEXP=0 IMAX=0.0020128 FREV=1000 CJORBOT=0.00085856 CJORSTI=2.4557e-11 CJORGAT=1.3846e-11 VBIRBOT=0.74373 VBIRSTI=1.597 VBIRGAT=0.6629 PBOT=0.27424 PSTI=0.16571 PGAT=0.1451 CJORBOTD=0.001 CJORSTID=1e-09 CJORGATD=1e-09 VBIRBOTD=1 VBIRSTID=1 VBIRGATD=1 PBOTD=0.5 PSTID=0.5 PGATD=0.5 PHIGBOT=1.1984 PHIGSTI=1.006 PHIGGAT=0.3 IDSATRBOT=5.397e-08 IDSATRSTI=4.0612e-15 IDSATRGAT=0 CSRHBOT=100 CSRHSTI=0.0001 CSRHGAT=0.0001 XJUNSTI=1.61e-08 XJUNGAT=6.134e-07 PHIGBOTD=1.16 PHIGSTID=1.16 PHIGGATD=1.16 IDSATRBOTD=1e-12 IDSATRSTID=1e-18 IDSATRGATD=1e-18 CSRHBOTD=100 CSRHSTID=0.0001 CSRHGATD=0.0001 XJUNSTID=1e-07 XJUNGATD=1e-07 CTATBOT=100 CTATSTI=0.0001 CTATGAT=0.0001 MEFFTATBOT=0.25 MEFFTATSTI=0.25 MEFFTATGAT=0.25 CTATBOTD=100 CTATSTID=0.0001 CTATGATD=0.0001 MEFFTATBOTD=0.25 MEFFTATSTID=0.25 MEFFTATGATD=0.25 CBBTBOT=1e-12 CBBTSTI=1e-21 CBBTGAT=1e-18 FBBTRBOT=1000000000 FBBTRSTI=1000000000 FBBTRGAT=1000000000 STFBBTBOT=-0.001 STFBBTSTI=-0.001 STFBBTGAT=-0.001 CBBTBOTD=1e-12 CBBTSTID=1e-18 CBBTGATD=1e-18 FBBTRBOTD=1000000000 FBBTRSTID=1000000000 FBBTRGATD=1000000000 STFBBTBOTD=-0.001 STFBBTSTID=-0.001 STFBBTGATD=-0.001 VBRBOT=10 VBRSTI=10 VBRGAT=10 PBRBOT=4 PBRSTI=4 PBRGAT=4 VBRBOTD=10 VBRSTID=10 VBRGATD=10 PBRBOTD=4 PBRSTID=4 PBRGATD=4 VJUNREF=2.5 FJUNQ=0.03 VJUNREFD=2.5 FJUNQD=0.03 RINT=3.0856e-12 RVPOLY=0 DLSIL=0 RSH=0 RSHD=0 CFRW=6e-17 RSHG=20 RGO=35 RBULKO=386.9230246 RWELLO=386.9230246 RJUNSO=967.3075615 RJUNDO=967.3075615 SWSOA=0 VGS_MAX=3 VGD_MAX=3 VGB_MAX=3 VDS_MAX=3 VDB_MAX=1.6 VSB_MAX=1.6
model hvn_w10876n_l2000n_ng2 PSP103VA TYPE=1 TR=27 DTA=0 SWGEO=1 SWIGATE=1 SWIMPACT=1 SWGIDL=0 SWJUNCAP=3 SWJUNASYM=0 SWNUD=0 SWEDGE=0 SWDELVTAC=0 SWIGN=1 QMC=1 LVARO=3.499e-08 LVARL=-0.09125 LVARW=0 LAP=6.3866e-08 WVARO=0 WVARL=0 WVARW=0 WOT=3e-08 DLQ=5.2202e-08 DWQ=3e-08 VFBO=-0.89839 VFBL=0.15096 VFBW=0.0017033 VFBLW=0.019398 STVFBO=0.0008739 STVFBL=0.00014864 STVFBW=-4.6174e-05 STVFBLW=-2.445e-06 ST2VFBO=0 TOXO=7.4256e-09 EPSROXO=3.9 NSUBO=1.8552e+23 NSUBW=-0.0050198 WSEG=1.098e-10 NPCK=3.178e+23 NPCKW=-2.7604 WSEGP=1e-08 LPCK=1e-08 LPCKW=0 FOL1=0.21033 FOL2=0.0026472 FACNEFFACO=1 FACNEFFACL=0 FACNEFFACW=0 FACNEFFACLW=0 GFACNUDO=1 GFACNUDL=0 GFACNUDLEXP=1 GFACNUDW=0 GFACNUDLW=0 VSBNUDO=0 DVSBNUDO=1 VNSUBO=0 NSLPO=0.05 DNSUBO=0.025686 DPHIBO=-0.0607576464 DPHIBL=-0.00546403785 DPHIBLEXP=2.3956 DPHIBW=0.014614 DPHIBLW=-0.017476272 DELVTACO=0 DELVTACL=0 DELVTACLEXP=1 DELVTACW=0 DELVTACLW=0 NPO=3.897e+26 NPL=-0.1215 TOXOVO=7.4256e-09 TOXOVDO=2e-09 LOV=6.3866e-08 LOVD=0 NOVO=5.5814e+24 NOVDO=5e+25 CTO=-0.061658 CTL=0.025 CTLEXP=1.6063 CTW=-0.044911 CTLW=-0.0077386 CTGO=0 CTBO=0 STCTO=1 CFL=0.0048288 CFLEXP=1.3328 CFW=0.037319 CFBO=0.26069 CFDO=0 PSCEL=0 PSCELEXP=2 PSCEW=0 PSCEBO=0 PSCEDO=0 UO=0.046687 FBET1=-0.35712 FBET1W=-0.14995 LP1=4.5615e-08 LP1W=0.4189 FBET2=-1.0245 LP2=9.42e-09 BETW1=0.6567 BETW2=-0.083639 WBET=1.0063e-10 STBETO=1.6942 STBETL=-0.0065587 STBETW=-0.060053 STBETLW=0.00036994 MUEO=0.91692524 MUEW=-0.018226 STMUEO=0.34067 THEMUO=2.5509 STTHEMUO=0.63756 CSO=2.0494 CSL=-0.97261 CSLEXP=0 CSW=0.044205 CSLW=-1.0021 STCSO=2.5545 THECSO=2 STTHECSO=0 XCORO=0.04872 XCORL=-0.27137 XCORW=-0.1948 XCORLW=0 STXCORO=1.1327 FETAO=1.0706 RSW1=321.598966 RSW2=-0.07 STRSO=-0.058157 RSBO=-0.0025425 RSGO=0.10986 THESATO=0.1 THESATL=0.446499 THESATLEXP=1.0973 THESATW=0.082797 THESATLW=-0.032897685 STTHESATO=0.48396 STTHESATL=0.50226 STTHESATW=0.049985 STTHESATLW=-0.059487 THESATBO=0.06 THESATGO=0.050814 AXO=8.7694 AXL=2.3029 ALPL=0.0019702 ALPLEXP=1.4003 ALPW=1.1052 ALP1L1=0.007475 ALP1LEXP=0.80983 ALP1L2=0.719 ALP1W=0.56703 ALP2L1=5.413e-07 ALP2LEXP=0.2541 ALP2L2=0 ALP2W=-10 VPO=0.06567 A1O=4.7288 A1L=0.052459 A1W=0.024056 A2O=22.013 STA2O=0.018532 A3O=1.2047 A3L=-0.10308 A3W=0.0069117 A4O=0.12894 A4L=-0.05413 A4W=-0.06197 GCOO=0 IGINVLW=0 IGOVW=0 IGOVDW=0 STIGO=2 GC2O=0.375 GC3O=0.063 CHIBO=3.1 AGIDLW=70 AGIDLDW=0 BGIDLO=13 BGIDLDO=41 STBGIDLO=-0.001067 STBGIDLDO=0 CGIDLO=0 CGIDLDO=0 CGBOVL=2.522e-16 CFRDW=0 FNTO=1 FNTEXCL=0 NFALW=1.42e+25 NFBLW=574300000 NFCLW=-3.015e-08 EFO=1 LINTNOI=-3.158e-08 ALPNOI=2.708 WEDGE=1e-08 WEDGEW=0 VFBEDGEO=-1 STVFBEDGEO=0.0005 STVFBEDGEL=0 STVFBEDGEW=0 STVFBEDGELW=0 DPHIBEDGEO=0 DPHIBEDGEL=0 DPHIBEDGELEXP=1 DPHIBEDGEW=0 DPHIBEDGELW=0 NSUBEDGEO=5e+23 NSUBEDGEL=0 NSUBEDGELEXP=1 NSUBEDGEW=0 NSUBEDGELW=0 CTEDGEO=0 CTEDGEL=0 CTEDGELEXP=1 FBETEDGE=0 LPEDGE=1e-08 BETEDGEW=0 STBETEDGEO=1 STBETEDGEL=0 STBETEDGEW=0 STBETEDGELW=0 PSCEEDGEL=0 PSCEEDGELEXP=2 PSCEEDGEW=0 PSCEBEDGEO=0 PSCEDEDGEO=0 CFEDGEL=0 CFEDGELEXP=2 CFEDGEW=0 CFDEDGEO=0 CFBEDGEO=0 FNTEDGEO=1 NFAEDGELW=8e+22 NFBEDGELW=30000000 NFCEDGELW=0 EFEDGEO=1 SAREF=1e-06 SBREF=1e-06 WLOD=0 KUO=0 KVSAT=0 TKUO=0 LKUO=0 WKUO=0 PKUO=0 LLODKUO=0 WLODKUO=0 KVTHO=0 LKVTHO=0 WKVTHO=0 PKVTHO=0 LLODVTH=0 WLODVTH=0 STETAO=0 LODETAO=1 SCREF=1e-06 WEB=0 WEC=0 KVTHOWEO=0 KVTHOWEL=0 KVTHOWEW=0 KVTHOWELW=0 KUOWEO=0 KUOWEL=0 KUOWEW=0 KUOWELW=0 TRJ=21 SWJUNEXP=0 IMAX=0.0020128 FREV=1000 CJORBOT=0.00085856 CJORSTI=2.4557e-11 CJORGAT=1.3846e-11 VBIRBOT=0.74373 VBIRSTI=1.597 VBIRGAT=0.6629 PBOT=0.27424 PSTI=0.16571 PGAT=0.1451 CJORBOTD=0.001 CJORSTID=1e-09 CJORGATD=1e-09 VBIRBOTD=1 VBIRSTID=1 VBIRGATD=1 PBOTD=0.5 PSTID=0.5 PGATD=0.5 PHIGBOT=1.1984 PHIGSTI=1.006 PHIGGAT=0.3 IDSATRBOT=5.397e-08 IDSATRSTI=4.0612e-15 IDSATRGAT=0 CSRHBOT=100 CSRHSTI=0.0001 CSRHGAT=0.0001 XJUNSTI=1.61e-08 XJUNGAT=6.134e-07 PHIGBOTD=1.16 PHIGSTID=1.16 PHIGGATD=1.16 IDSATRBOTD=1e-12 IDSATRSTID=1e-18 IDSATRGATD=1e-18 CSRHBOTD=100 CSRHSTID=0.0001 CSRHGATD=0.0001 XJUNSTID=1e-07 XJUNGATD=1e-07 CTATBOT=100 CTATSTI=0.0001 CTATGAT=0.0001 MEFFTATBOT=0.25 MEFFTATSTI=0.25 MEFFTATGAT=0.25 CTATBOTD=100 CTATSTID=0.0001 CTATGATD=0.0001 MEFFTATBOTD=0.25 MEFFTATSTID=0.25 MEFFTATGATD=0.25 CBBTBOT=1e-12 CBBTSTI=1e-21 CBBTGAT=1e-18 FBBTRBOT=1000000000 FBBTRSTI=1000000000 FBBTRGAT=1000000000 STFBBTBOT=-0.001 STFBBTSTI=-0.001 STFBBTGAT=-0.001 CBBTBOTD=1e-12 CBBTSTID=1e-18 CBBTGATD=1e-18 FBBTRBOTD=1000000000 FBBTRSTID=1000000000 FBBTRGATD=1000000000 STFBBTBOTD=-0.001 STFBBTSTID=-0.001 STFBBTGATD=-0.001 VBRBOT=10 VBRSTI=10 VBRGAT=10 PBRBOT=4 PBRSTI=4 PBRGAT=4 VBRBOTD=10 VBRSTID=10 VBRGATD=10 PBRBOTD=4 PBRSTID=4 PBRGATD=4 VJUNREF=2.5 FJUNQ=0.03 VJUNREFD=2.5 FJUNQD=0.03 RINT=3.0856e-12 RVPOLY=0 DLSIL=0 RSH=0 RSHD=0 CFRW=6e-17 RSHG=20 RGO=35 RBULKO=367.767977 RWELLO=367.767977 RJUNSO=919.4199426 RJUNDO=919.4199426 SWSOA=0 VGS_MAX=3 VGD_MAX=3 VGB_MAX=3 VDS_MAX=3 VDB_MAX=1.6 VSB_MAX=1.6
model hvn_w11318n_l2000n_ng2 PSP103VA TYPE=1 TR=27 DTA=0 SWGEO=1 SWIGATE=1 SWIMPACT=1 SWGIDL=0 SWJUNCAP=3 SWJUNASYM=0 SWNUD=0 SWEDGE=0 SWDELVTAC=0 SWIGN=1 QMC=1 LVARO=3.499e-08 LVARL=-0.09125 LVARW=0 LAP=6.3866e-08 WVARO=0 WVARL=0 WVARW=0 WOT=3e-08 DLQ=5.2202e-08 DWQ=3e-08 VFBO=-0.89839 VFBL=0.15096 VFBW=0.0017033 VFBLW=0.019398 STVFBO=0.0008739 STVFBL=0.00014864 STVFBW=-4.6174e-05 STVFBLW=-2.445e-06 ST2VFBO=0 TOXO=7.4256e-09 EPSROXO=3.9 NSUBO=1.8552e+23 NSUBW=-0.0050198 WSEG=1.098e-10 NPCK=3.178e+23 NPCKW=-2.7604 WSEGP=1e-08 LPCK=1e-08 LPCKW=0 FOL1=0.21033 FOL2=0.0026472 FACNEFFACO=1 FACNEFFACL=0 FACNEFFACW=0 FACNEFFACLW=0 GFACNUDO=1 GFACNUDL=0 GFACNUDLEXP=1 GFACNUDW=0 GFACNUDLW=0 VSBNUDO=0 DVSBNUDO=1 VNSUBO=0 NSLPO=0.05 DNSUBO=0.025686 DPHIBO=-0.0607576464 DPHIBL=-0.00546403785 DPHIBLEXP=2.3956 DPHIBW=0.014614 DPHIBLW=-0.017476272 DELVTACO=0 DELVTACL=0 DELVTACLEXP=1 DELVTACW=0 DELVTACLW=0 NPO=3.897e+26 NPL=-0.1215 TOXOVO=7.4256e-09 TOXOVDO=2e-09 LOV=6.3866e-08 LOVD=0 NOVO=5.5814e+24 NOVDO=5e+25 CTO=-0.061658 CTL=0.025 CTLEXP=1.6063 CTW=-0.044911 CTLW=-0.0077386 CTGO=0 CTBO=0 STCTO=1 CFL=0.0048288 CFLEXP=1.3328 CFW=0.037319 CFBO=0.26069 CFDO=0 PSCEL=0 PSCELEXP=2 PSCEW=0 PSCEBO=0 PSCEDO=0 UO=0.046687 FBET1=-0.35712 FBET1W=-0.14995 LP1=4.5615e-08 LP1W=0.4189 FBET2=-1.0245 LP2=9.42e-09 BETW1=0.6567 BETW2=-0.083639 WBET=1.0063e-10 STBETO=1.6942 STBETL=-0.0065587 STBETW=-0.060053 STBETLW=0.00036994 MUEO=0.91692524 MUEW=-0.018226 STMUEO=0.34067 THEMUO=2.5509 STTHEMUO=0.63756 CSO=2.0494 CSL=-0.97261 CSLEXP=0 CSW=0.044205 CSLW=-1.0021 STCSO=2.5545 THECSO=2 STTHECSO=0 XCORO=0.04872 XCORL=-0.27137 XCORW=-0.1948 XCORLW=0 STXCORO=1.1327 FETAO=1.0706 RSW1=321.598966 RSW2=-0.07 STRSO=-0.058157 RSBO=-0.0025425 RSGO=0.10986 THESATO=0.1 THESATL=0.446499 THESATLEXP=1.0973 THESATW=0.082797 THESATLW=-0.032897685 STTHESATO=0.48396 STTHESATL=0.50226 STTHESATW=0.049985 STTHESATLW=-0.059487 THESATBO=0.06 THESATGO=0.050814 AXO=8.7694 AXL=2.3029 ALPL=0.0019702 ALPLEXP=1.4003 ALPW=1.1052 ALP1L1=0.007475 ALP1LEXP=0.80983 ALP1L2=0.719 ALP1W=0.56703 ALP2L1=5.413e-07 ALP2LEXP=0.2541 ALP2L2=0 ALP2W=-10 VPO=0.06567 A1O=4.7288 A1L=0.052459 A1W=0.024056 A2O=22.013 STA2O=0.018532 A3O=1.2047 A3L=-0.10308 A3W=0.0069117 A4O=0.12894 A4L=-0.05413 A4W=-0.06197 GCOO=0 IGINVLW=0 IGOVW=0 IGOVDW=0 STIGO=2 GC2O=0.375 GC3O=0.063 CHIBO=3.1 AGIDLW=70 AGIDLDW=0 BGIDLO=13 BGIDLDO=41 STBGIDLO=-0.001067 STBGIDLDO=0 CGIDLO=0 CGIDLDO=0 CGBOVL=2.522e-16 CFRDW=0 FNTO=1 FNTEXCL=0 NFALW=1.42e+25 NFBLW=574300000 NFCLW=-3.015e-08 EFO=1 LINTNOI=-3.158e-08 ALPNOI=2.708 WEDGE=1e-08 WEDGEW=0 VFBEDGEO=-1 STVFBEDGEO=0.0005 STVFBEDGEL=0 STVFBEDGEW=0 STVFBEDGELW=0 DPHIBEDGEO=0 DPHIBEDGEL=0 DPHIBEDGELEXP=1 DPHIBEDGEW=0 DPHIBEDGELW=0 NSUBEDGEO=5e+23 NSUBEDGEL=0 NSUBEDGELEXP=1 NSUBEDGEW=0 NSUBEDGELW=0 CTEDGEO=0 CTEDGEL=0 CTEDGELEXP=1 FBETEDGE=0 LPEDGE=1e-08 BETEDGEW=0 STBETEDGEO=1 STBETEDGEL=0 STBETEDGEW=0 STBETEDGELW=0 PSCEEDGEL=0 PSCEEDGELEXP=2 PSCEEDGEW=0 PSCEBEDGEO=0 PSCEDEDGEO=0 CFEDGEL=0 CFEDGELEXP=2 CFEDGEW=0 CFDEDGEO=0 CFBEDGEO=0 FNTEDGEO=1 NFAEDGELW=8e+22 NFBEDGELW=30000000 NFCEDGELW=0 EFEDGEO=1 SAREF=1e-06 SBREF=1e-06 WLOD=0 KUO=0 KVSAT=0 TKUO=0 LKUO=0 WKUO=0 PKUO=0 LLODKUO=0 WLODKUO=0 KVTHO=0 LKVTHO=0 WKVTHO=0 PKVTHO=0 LLODVTH=0 WLODVTH=0 STETAO=0 LODETAO=1 SCREF=1e-06 WEB=0 WEC=0 KVTHOWEO=0 KVTHOWEL=0 KVTHOWEW=0 KVTHOWELW=0 KUOWEO=0 KUOWEL=0 KUOWEW=0 KUOWELW=0 TRJ=21 SWJUNEXP=0 IMAX=0.0020128 FREV=1000 CJORBOT=0.00085856 CJORSTI=2.4557e-11 CJORGAT=1.3846e-11 VBIRBOT=0.74373 VBIRSTI=1.597 VBIRGAT=0.6629 PBOT=0.27424 PSTI=0.16571 PGAT=0.1451 CJORBOTD=0.001 CJORSTID=1e-09 CJORGATD=1e-09 VBIRBOTD=1 VBIRSTID=1 VBIRGATD=1 PBOTD=0.5 PSTID=0.5 PGATD=0.5 PHIGBOT=1.1984 PHIGSTI=1.006 PHIGGAT=0.3 IDSATRBOT=5.397e-08 IDSATRSTI=4.0612e-15 IDSATRGAT=0 CSRHBOT=100 CSRHSTI=0.0001 CSRHGAT=0.0001 XJUNSTI=1.61e-08 XJUNGAT=6.134e-07 PHIGBOTD=1.16 PHIGSTID=1.16 PHIGGATD=1.16 IDSATRBOTD=1e-12 IDSATRSTID=1e-18 IDSATRGATD=1e-18 CSRHBOTD=100 CSRHSTID=0.0001 CSRHGATD=0.0001 XJUNSTID=1e-07 XJUNGATD=1e-07 CTATBOT=100 CTATSTI=0.0001 CTATGAT=0.0001 MEFFTATBOT=0.25 MEFFTATSTI=0.25 MEFFTATGAT=0.25 CTATBOTD=100 CTATSTID=0.0001 CTATGATD=0.0001 MEFFTATBOTD=0.25 MEFFTATSTID=0.25 MEFFTATGATD=0.25 CBBTBOT=1e-12 CBBTSTI=1e-21 CBBTGAT=1e-18 FBBTRBOT=1000000000 FBBTRSTI=1000000000 FBBTRGAT=1000000000 STFBBTBOT=-0.001 STFBBTSTI=-0.001 STFBBTGAT=-0.001 CBBTBOTD=1e-12 CBBTSTID=1e-18 CBBTGATD=1e-18 FBBTRBOTD=1000000000 FBBTRSTID=1000000000 FBBTRGATD=1000000000 STFBBTBOTD=-0.001 STFBBTSTID=-0.001 STFBBTGATD=-0.001 VBRBOT=10 VBRSTI=10 VBRGAT=10 PBRBOT=4 PBRSTI=4 PBRGAT=4 VBRBOTD=10 VBRSTID=10 VBRGATD=10 PBRBOTD=4 PBRSTID=4 PBRGATD=4 VJUNREF=2.5 FJUNQ=0.03 VJUNREFD=2.5 FJUNQD=0.03 RINT=3.0856e-12 RVPOLY=0 DLSIL=0 RSH=0 RSHD=0 CFRW=6e-17 RSHG=20 RGO=35 RBULKO=353.4315247 RWELLO=353.4315247 RJUNSO=883.5788116 RJUNDO=883.5788116 SWSOA=0 VGS_MAX=3 VGD_MAX=3 VGB_MAX=3 VDS_MAX=3 VDB_MAX=1.6 VSB_MAX=1.6
model hvn_w12000n_l2000n_ng2 PSP103VA TYPE=1 TR=27 DTA=0 SWGEO=1 SWIGATE=1 SWIMPACT=1 SWGIDL=0 SWJUNCAP=3 SWJUNASYM=0 SWNUD=0 SWEDGE=0 SWDELVTAC=0 SWIGN=1 QMC=1 LVARO=3.499e-08 LVARL=-0.09125 LVARW=0 LAP=6.3866e-08 WVARO=0 WVARL=0 WVARW=0 WOT=3e-08 DLQ=5.2202e-08 DWQ=3e-08 VFBO=-0.89839 VFBL=0.15096 VFBW=0.0017033 VFBLW=0.019398 STVFBO=0.0008739 STVFBL=0.00014864 STVFBW=-4.6174e-05 STVFBLW=-2.445e-06 ST2VFBO=0 TOXO=7.4256e-09 EPSROXO=3.9 NSUBO=1.8552e+23 NSUBW=-0.0050198 WSEG=1.098e-10 NPCK=3.178e+23 NPCKW=-2.7604 WSEGP=1e-08 LPCK=1e-08 LPCKW=0 FOL1=0.21033 FOL2=0.0026472 FACNEFFACO=1 FACNEFFACL=0 FACNEFFACW=0 FACNEFFACLW=0 GFACNUDO=1 GFACNUDL=0 GFACNUDLEXP=1 GFACNUDW=0 GFACNUDLW=0 VSBNUDO=0 DVSBNUDO=1 VNSUBO=0 NSLPO=0.05 DNSUBO=0.025686 DPHIBO=-0.0607576464 DPHIBL=-0.00546403785 DPHIBLEXP=2.3956 DPHIBW=0.014614 DPHIBLW=-0.017476272 DELVTACO=0 DELVTACL=0 DELVTACLEXP=1 DELVTACW=0 DELVTACLW=0 NPO=3.897e+26 NPL=-0.1215 TOXOVO=7.4256e-09 TOXOVDO=2e-09 LOV=6.3866e-08 LOVD=0 NOVO=5.5814e+24 NOVDO=5e+25 CTO=-0.061658 CTL=0.025 CTLEXP=1.6063 CTW=-0.044911 CTLW=-0.0077386 CTGO=0 CTBO=0 STCTO=1 CFL=0.0048288 CFLEXP=1.3328 CFW=0.037319 CFBO=0.26069 CFDO=0 PSCEL=0 PSCELEXP=2 PSCEW=0 PSCEBO=0 PSCEDO=0 UO=0.046687 FBET1=-0.35712 FBET1W=-0.14995 LP1=4.5615e-08 LP1W=0.4189 FBET2=-1.0245 LP2=9.42e-09 BETW1=0.6567 BETW2=-0.083639 WBET=1.0063e-10 STBETO=1.6942 STBETL=-0.0065587 STBETW=-0.060053 STBETLW=0.00036994 MUEO=0.91692524 MUEW=-0.018226 STMUEO=0.34067 THEMUO=2.5509 STTHEMUO=0.63756 CSO=2.0494 CSL=-0.97261 CSLEXP=0 CSW=0.044205 CSLW=-1.0021 STCSO=2.5545 THECSO=2 STTHECSO=0 XCORO=0.04872 XCORL=-0.27137 XCORW=-0.1948 XCORLW=0 STXCORO=1.1327 FETAO=1.0706 RSW1=321.598966 RSW2=-0.07 STRSO=-0.058157 RSBO=-0.0025425 RSGO=0.10986 THESATO=0.1 THESATL=0.446499 THESATLEXP=1.0973 THESATW=0.082797 THESATLW=-0.032897685 STTHESATO=0.48396 STTHESATL=0.50226 STTHESATW=0.049985 STTHESATLW=-0.059487 THESATBO=0.06 THESATGO=0.050814 AXO=8.7694 AXL=2.3029 ALPL=0.0019702 ALPLEXP=1.4003 ALPW=1.1052 ALP1L1=0.007475 ALP1LEXP=0.80983 ALP1L2=0.719 ALP1W=0.56703 ALP2L1=5.413e-07 ALP2LEXP=0.2541 ALP2L2=0 ALP2W=-10 VPO=0.06567 A1O=4.7288 A1L=0.052459 A1W=0.024056 A2O=22.013 STA2O=0.018532 A3O=1.2047 A3L=-0.10308 A3W=0.0069117 A4O=0.12894 A4L=-0.05413 A4W=-0.06197 GCOO=0 IGINVLW=0 IGOVW=0 IGOVDW=0 STIGO=2 GC2O=0.375 GC3O=0.063 CHIBO=3.1 AGIDLW=70 AGIDLDW=0 BGIDLO=13 BGIDLDO=41 STBGIDLO=-0.001067 STBGIDLDO=0 CGIDLO=0 CGIDLDO=0 CGBOVL=2.522e-16 CFRDW=0 FNTO=1 FNTEXCL=0 NFALW=1.42e+25 NFBLW=574300000 NFCLW=-3.015e-08 EFO=1 LINTNOI=-3.158e-08 ALPNOI=2.708 WEDGE=1e-08 WEDGEW=0 VFBEDGEO=-1 STVFBEDGEO=0.0005 STVFBEDGEL=0 STVFBEDGEW=0 STVFBEDGELW=0 DPHIBEDGEO=0 DPHIBEDGEL=0 DPHIBEDGELEXP=1 DPHIBEDGEW=0 DPHIBEDGELW=0 NSUBEDGEO=5e+23 NSUBEDGEL=0 NSUBEDGELEXP=1 NSUBEDGEW=0 NSUBEDGELW=0 CTEDGEO=0 CTEDGEL=0 CTEDGELEXP=1 FBETEDGE=0 LPEDGE=1e-08 BETEDGEW=0 STBETEDGEO=1 STBETEDGEL=0 STBETEDGEW=0 STBETEDGELW=0 PSCEEDGEL=0 PSCEEDGELEXP=2 PSCEEDGEW=0 PSCEBEDGEO=0 PSCEDEDGEO=0 CFEDGEL=0 CFEDGELEXP=2 CFEDGEW=0 CFDEDGEO=0 CFBEDGEO=0 FNTEDGEO=1 NFAEDGELW=8e+22 NFBEDGELW=30000000 NFCEDGELW=0 EFEDGEO=1 SAREF=1e-06 SBREF=1e-06 WLOD=0 KUO=0 KVSAT=0 TKUO=0 LKUO=0 WKUO=0 PKUO=0 LLODKUO=0 WLODKUO=0 KVTHO=0 LKVTHO=0 WKVTHO=0 PKVTHO=0 LLODVTH=0 WLODVTH=0 STETAO=0 LODETAO=1 SCREF=1e-06 WEB=0 WEC=0 KVTHOWEO=0 KVTHOWEL=0 KVTHOWEW=0 KVTHOWELW=0 KUOWEO=0 KUOWEL=0 KUOWEW=0 KUOWELW=0 TRJ=21 SWJUNEXP=0 IMAX=0.0020128 FREV=1000 CJORBOT=0.00085856 CJORSTI=2.4557e-11 CJORGAT=1.3846e-11 VBIRBOT=0.74373 VBIRSTI=1.597 VBIRGAT=0.6629 PBOT=0.27424 PSTI=0.16571 PGAT=0.1451 CJORBOTD=0.001 CJORSTID=1e-09 CJORGATD=1e-09 VBIRBOTD=1 VBIRSTID=1 VBIRGATD=1 PBOTD=0.5 PSTID=0.5 PGATD=0.5 PHIGBOT=1.1984 PHIGSTI=1.006 PHIGGAT=0.3 IDSATRBOT=5.397e-08 IDSATRSTI=4.0612e-15 IDSATRGAT=0 CSRHBOT=100 CSRHSTI=0.0001 CSRHGAT=0.0001 XJUNSTI=1.61e-08 XJUNGAT=6.134e-07 PHIGBOTD=1.16 PHIGSTID=1.16 PHIGGATD=1.16 IDSATRBOTD=1e-12 IDSATRSTID=1e-18 IDSATRGATD=1e-18 CSRHBOTD=100 CSRHSTID=0.0001 CSRHGATD=0.0001 XJUNSTID=1e-07 XJUNGATD=1e-07 CTATBOT=100 CTATSTI=0.0001 CTATGAT=0.0001 MEFFTATBOT=0.25 MEFFTATSTI=0.25 MEFFTATGAT=0.25 CTATBOTD=100 CTATSTID=0.0001 CTATGATD=0.0001 MEFFTATBOTD=0.25 MEFFTATSTID=0.25 MEFFTATGATD=0.25 CBBTBOT=1e-12 CBBTSTI=1e-21 CBBTGAT=1e-18 FBBTRBOT=1000000000 FBBTRSTI=1000000000 FBBTRGAT=1000000000 STFBBTBOT=-0.001 STFBBTSTI=-0.001 STFBBTGAT=-0.001 CBBTBOTD=1e-12 CBBTSTID=1e-18 CBBTGATD=1e-18 FBBTRBOTD=1000000000 FBBTRSTID=1000000000 FBBTRGATD=1000000000 STFBBTBOTD=-0.001 STFBBTSTID=-0.001 STFBBTGATD=-0.001 VBRBOT=10 VBRSTI=10 VBRGAT=10 PBRBOT=4 PBRSTI=4 PBRGAT=4 VBRBOTD=10 VBRSTID=10 VBRGATD=10 PBRBOTD=4 PBRSTID=4 PBRGATD=4 VJUNREF=2.5 FJUNQ=0.03 VJUNREFD=2.5 FJUNQD=0.03 RINT=3.0856e-12 RVPOLY=0 DLSIL=0 RSH=0 RSHD=0 CFRW=6e-17 RSHG=20 RGO=35 RBULKO=333.3333333 RWELLO=333.3333333 RJUNSO=833.3333333 RJUNDO=833.3333333 SWSOA=0 VGS_MAX=3 VGD_MAX=3 VGB_MAX=3 VDS_MAX=3 VDB_MAX=1.6 VSB_MAX=1.6
model hvn_w17050n_l2000n_ng2 PSP103VA TYPE=1 TR=27 DTA=0 SWGEO=1 SWIGATE=1 SWIMPACT=1 SWGIDL=0 SWJUNCAP=3 SWJUNASYM=0 SWNUD=0 SWEDGE=0 SWDELVTAC=0 SWIGN=1 QMC=1 LVARO=3.499e-08 LVARL=-0.09125 LVARW=0 LAP=6.3866e-08 WVARO=0 WVARL=0 WVARW=0 WOT=3e-08 DLQ=5.2202e-08 DWQ=3e-08 VFBO=-0.89839 VFBL=0.15096 VFBW=0.0017033 VFBLW=0.019398 STVFBO=0.0008739 STVFBL=0.00014864 STVFBW=-4.6174e-05 STVFBLW=-2.445e-06 ST2VFBO=0 TOXO=7.4256e-09 EPSROXO=3.9 NSUBO=1.8552e+23 NSUBW=-0.0050198 WSEG=1.098e-10 NPCK=3.178e+23 NPCKW=-2.7604 WSEGP=1e-08 LPCK=1e-08 LPCKW=0 FOL1=0.21033 FOL2=0.0026472 FACNEFFACO=1 FACNEFFACL=0 FACNEFFACW=0 FACNEFFACLW=0 GFACNUDO=1 GFACNUDL=0 GFACNUDLEXP=1 GFACNUDW=0 GFACNUDLW=0 VSBNUDO=0 DVSBNUDO=1 VNSUBO=0 NSLPO=0.05 DNSUBO=0.025686 DPHIBO=-0.0607576464 DPHIBL=-0.00546403785 DPHIBLEXP=2.3956 DPHIBW=0.014614 DPHIBLW=-0.017476272 DELVTACO=0 DELVTACL=0 DELVTACLEXP=1 DELVTACW=0 DELVTACLW=0 NPO=3.897e+26 NPL=-0.1215 TOXOVO=7.4256e-09 TOXOVDO=2e-09 LOV=6.3866e-08 LOVD=0 NOVO=5.5814e+24 NOVDO=5e+25 CTO=-0.061658 CTL=0.025 CTLEXP=1.6063 CTW=-0.044911 CTLW=-0.0077386 CTGO=0 CTBO=0 STCTO=1 CFL=0.0048288 CFLEXP=1.3328 CFW=0.037319 CFBO=0.26069 CFDO=0 PSCEL=0 PSCELEXP=2 PSCEW=0 PSCEBO=0 PSCEDO=0 UO=0.046687 FBET1=-0.35712 FBET1W=-0.14995 LP1=4.5615e-08 LP1W=0.4189 FBET2=-1.0245 LP2=9.42e-09 BETW1=0.6567 BETW2=-0.083639 WBET=1.0063e-10 STBETO=1.6942 STBETL=-0.0065587 STBETW=-0.060053 STBETLW=0.00036994 MUEO=0.91692524 MUEW=-0.018226 STMUEO=0.34067 THEMUO=2.5509 STTHEMUO=0.63756 CSO=2.0494 CSL=-0.97261 CSLEXP=0 CSW=0.044205 CSLW=-1.0021 STCSO=2.5545 THECSO=2 STTHECSO=0 XCORO=0.04872 XCORL=-0.27137 XCORW=-0.1948 XCORLW=0 STXCORO=1.1327 FETAO=1.0706 RSW1=321.598966 RSW2=-0.07 STRSO=-0.058157 RSBO=-0.0025425 RSGO=0.10986 THESATO=0.1 THESATL=0.446499 THESATLEXP=1.0973 THESATW=0.082797 THESATLW=-0.032897685 STTHESATO=0.48396 STTHESATL=0.50226 STTHESATW=0.049985 STTHESATLW=-0.059487 THESATBO=0.06 THESATGO=0.050814 AXO=8.7694 AXL=2.3029 ALPL=0.0019702 ALPLEXP=1.4003 ALPW=1.1052 ALP1L1=0.007475 ALP1LEXP=0.80983 ALP1L2=0.719 ALP1W=0.56703 ALP2L1=5.413e-07 ALP2LEXP=0.2541 ALP2L2=0 ALP2W=-10 VPO=0.06567 A1O=4.7288 A1L=0.052459 A1W=0.024056 A2O=22.013 STA2O=0.018532 A3O=1.2047 A3L=-0.10308 A3W=0.0069117 A4O=0.12894 A4L=-0.05413 A4W=-0.06197 GCOO=0 IGINVLW=0 IGOVW=0 IGOVDW=0 STIGO=2 GC2O=0.375 GC3O=0.063 CHIBO=3.1 AGIDLW=70 AGIDLDW=0 BGIDLO=13 BGIDLDO=41 STBGIDLO=-0.001067 STBGIDLDO=0 CGIDLO=0 CGIDLDO=0 CGBOVL=2.522e-16 CFRDW=0 FNTO=1 FNTEXCL=0 NFALW=1.42e+25 NFBLW=574300000 NFCLW=-3.015e-08 EFO=1 LINTNOI=-3.158e-08 ALPNOI=2.708 WEDGE=1e-08 WEDGEW=0 VFBEDGEO=-1 STVFBEDGEO=0.0005 STVFBEDGEL=0 STVFBEDGEW=0 STVFBEDGELW=0 DPHIBEDGEO=0 DPHIBEDGEL=0 DPHIBEDGELEXP=1 DPHIBEDGEW=0 DPHIBEDGELW=0 NSUBEDGEO=5e+23 NSUBEDGEL=0 NSUBEDGELEXP=1 NSUBEDGEW=0 NSUBEDGELW=0 CTEDGEO=0 CTEDGEL=0 CTEDGELEXP=1 FBETEDGE=0 LPEDGE=1e-08 BETEDGEW=0 STBETEDGEO=1 STBETEDGEL=0 STBETEDGEW=0 STBETEDGELW=0 PSCEEDGEL=0 PSCEEDGELEXP=2 PSCEEDGEW=0 PSCEBEDGEO=0 PSCEDEDGEO=0 CFEDGEL=0 CFEDGELEXP=2 CFEDGEW=0 CFDEDGEO=0 CFBEDGEO=0 FNTEDGEO=1 NFAEDGELW=8e+22 NFBEDGELW=30000000 NFCEDGELW=0 EFEDGEO=1 SAREF=1e-06 SBREF=1e-06 WLOD=0 KUO=0 KVSAT=0 TKUO=0 LKUO=0 WKUO=0 PKUO=0 LLODKUO=0 WLODKUO=0 KVTHO=0 LKVTHO=0 WKVTHO=0 PKVTHO=0 LLODVTH=0 WLODVTH=0 STETAO=0 LODETAO=1 SCREF=1e-06 WEB=0 WEC=0 KVTHOWEO=0 KVTHOWEL=0 KVTHOWEW=0 KVTHOWELW=0 KUOWEO=0 KUOWEL=0 KUOWEW=0 KUOWELW=0 TRJ=21 SWJUNEXP=0 IMAX=0.0020128 FREV=1000 CJORBOT=0.00085856 CJORSTI=2.4557e-11 CJORGAT=1.3846e-11 VBIRBOT=0.74373 VBIRSTI=1.597 VBIRGAT=0.6629 PBOT=0.27424 PSTI=0.16571 PGAT=0.1451 CJORBOTD=0.001 CJORSTID=1e-09 CJORGATD=1e-09 VBIRBOTD=1 VBIRSTID=1 VBIRGATD=1 PBOTD=0.5 PSTID=0.5 PGATD=0.5 PHIGBOT=1.1984 PHIGSTI=1.006 PHIGGAT=0.3 IDSATRBOT=5.397e-08 IDSATRSTI=4.0612e-15 IDSATRGAT=0 CSRHBOT=100 CSRHSTI=0.0001 CSRHGAT=0.0001 XJUNSTI=1.61e-08 XJUNGAT=6.134e-07 PHIGBOTD=1.16 PHIGSTID=1.16 PHIGGATD=1.16 IDSATRBOTD=1e-12 IDSATRSTID=1e-18 IDSATRGATD=1e-18 CSRHBOTD=100 CSRHSTID=0.0001 CSRHGATD=0.0001 XJUNSTID=1e-07 XJUNGATD=1e-07 CTATBOT=100 CTATSTI=0.0001 CTATGAT=0.0001 MEFFTATBOT=0.25 MEFFTATSTI=0.25 MEFFTATGAT=0.25 CTATBOTD=100 CTATSTID=0.0001 CTATGATD=0.0001 MEFFTATBOTD=0.25 MEFFTATSTID=0.25 MEFFTATGATD=0.25 CBBTBOT=1e-12 CBBTSTI=1e-21 CBBTGAT=1e-18 FBBTRBOT=1000000000 FBBTRSTI=1000000000 FBBTRGAT=1000000000 STFBBTBOT=-0.001 STFBBTSTI=-0.001 STFBBTGAT=-0.001 CBBTBOTD=1e-12 CBBTSTID=1e-18 CBBTGATD=1e-18 FBBTRBOTD=1000000000 FBBTRSTID=1000000000 FBBTRGATD=1000000000 STFBBTBOTD=-0.001 STFBBTSTID=-0.001 STFBBTGATD=-0.001 VBRBOT=10 VBRSTI=10 VBRGAT=10 PBRBOT=4 PBRSTI=4 PBRGAT=4 VBRBOTD=10 VBRSTID=10 VBRGATD=10 PBRBOTD=4 PBRSTID=4 PBRGATD=4 VJUNREF=2.5 FJUNQ=0.03 VJUNREFD=2.5 FJUNQD=0.03 RINT=3.0856e-12 RVPOLY=0 DLSIL=0 RSH=0 RSHD=0 CFRW=6e-17 RSHG=20 RGO=35 RBULKO=234.5984 RWELLO=234.5984 RJUNSO=586.496 RJUNDO=586.496 SWSOA=0 VGS_MAX=3 VGD_MAX=3 VGB_MAX=3 VDS_MAX=3 VDB_MAX=1.6 VSB_MAX=1.6
model hvn_w17050n_l450n_ng2 PSP103VA TYPE=1 TR=27 DTA=0 SWGEO=1 SWIGATE=1 SWIMPACT=1 SWGIDL=0 SWJUNCAP=3 SWJUNASYM=0 SWNUD=0 SWEDGE=0 SWDELVTAC=0 SWIGN=1 QMC=1 LVARO=3.499e-08 LVARL=-0.09125 LVARW=0 LAP=6.3866e-08 WVARO=0 WVARL=0 WVARW=0 WOT=3e-08 DLQ=5.2202e-08 DWQ=3e-08 VFBO=-0.89839 VFBL=0.15096 VFBW=0.0017033 VFBLW=0.019398 STVFBO=0.0008739 STVFBL=0.00014864 STVFBW=-4.6174e-05 STVFBLW=-2.445e-06 ST2VFBO=0 TOXO=7.4256e-09 EPSROXO=3.9 NSUBO=1.8552e+23 NSUBW=-0.0050198 WSEG=1.098e-10 NPCK=3.178e+23 NPCKW=-2.7604 WSEGP=1e-08 LPCK=1e-08 LPCKW=0 FOL1=0.21033 FOL2=0.0026472 FACNEFFACO=1 FACNEFFACL=0 FACNEFFACW=0 FACNEFFACLW=0 GFACNUDO=1 GFACNUDL=0 GFACNUDLEXP=1 GFACNUDW=0 GFACNUDLW=0 VSBNUDO=0 DVSBNUDO=1 VNSUBO=0 NSLPO=0.05 DNSUBO=0.025686 DPHIBO=-0.0607576464 DPHIBL=-0.00546403785 DPHIBLEXP=2.3956 DPHIBW=0.014614 DPHIBLW=-0.017476272 DELVTACO=0 DELVTACL=0 DELVTACLEXP=1 DELVTACW=0 DELVTACLW=0 NPO=3.897e+26 NPL=-0.1215 TOXOVO=7.4256e-09 TOXOVDO=2e-09 LOV=6.3866e-08 LOVD=0 NOVO=5.5814e+24 NOVDO=5e+25 CTO=-0.061658 CTL=0.025 CTLEXP=1.6063 CTW=-0.044911 CTLW=-0.0077386 CTGO=0 CTBO=0 STCTO=1 CFL=0.0048288 CFLEXP=1.3328 CFW=0.037319 CFBO=0.26069 CFDO=0 PSCEL=0 PSCELEXP=2 PSCEW=0 PSCEBO=0 PSCEDO=0 UO=0.046687 FBET1=-0.35712 FBET1W=-0.14995 LP1=4.5615e-08 LP1W=0.4189 FBET2=-1.0245 LP2=9.42e-09 BETW1=0.6567 BETW2=-0.083639 WBET=1.0063e-10 STBETO=1.6942 STBETL=-0.0065587 STBETW=-0.060053 STBETLW=0.00036994 MUEO=0.91692524 MUEW=-0.018226 STMUEO=0.34067 THEMUO=2.5509 STTHEMUO=0.63756 CSO=2.0494 CSL=-0.97261 CSLEXP=0 CSW=0.044205 CSLW=-1.0021 STCSO=2.5545 THECSO=2 STTHECSO=0 XCORO=0.04872 XCORL=-0.27137 XCORW=-0.1948 XCORLW=0 STXCORO=1.1327 FETAO=1.0706 RSW1=321.598966 RSW2=-0.07 STRSO=-0.058157 RSBO=-0.0025425 RSGO=0.10986 THESATO=0.1 THESATL=0.446499 THESATLEXP=1.0973 THESATW=0.082797 THESATLW=-0.032897685 STTHESATO=0.48396 STTHESATL=0.50226 STTHESATW=0.049985 STTHESATLW=-0.059487 THESATBO=0.06 THESATGO=0.050814 AXO=8.7694 AXL=2.3029 ALPL=0.0019702 ALPLEXP=1.4003 ALPW=1.1052 ALP1L1=0.007475 ALP1LEXP=0.80983 ALP1L2=0.719 ALP1W=0.56703 ALP2L1=5.413e-07 ALP2LEXP=0.2541 ALP2L2=0 ALP2W=-10 VPO=0.06567 A1O=4.7288 A1L=0.052459 A1W=0.024056 A2O=22.013 STA2O=0.018532 A3O=1.2047 A3L=-0.10308 A3W=0.0069117 A4O=0.12894 A4L=-0.05413 A4W=-0.06197 GCOO=0 IGINVLW=0 IGOVW=0 IGOVDW=0 STIGO=2 GC2O=0.375 GC3O=0.063 CHIBO=3.1 AGIDLW=70 AGIDLDW=0 BGIDLO=13 BGIDLDO=41 STBGIDLO=-0.001067 STBGIDLDO=0 CGIDLO=0 CGIDLDO=0 CGBOVL=2.522e-16 CFRDW=0 FNTO=1 FNTEXCL=0 NFALW=1.42e+25 NFBLW=574300000 NFCLW=-3.015e-08 EFO=1 LINTNOI=-3.158e-08 ALPNOI=2.708 WEDGE=1e-08 WEDGEW=0 VFBEDGEO=-1 STVFBEDGEO=0.0005 STVFBEDGEL=0 STVFBEDGEW=0 STVFBEDGELW=0 DPHIBEDGEO=0 DPHIBEDGEL=0 DPHIBEDGELEXP=1 DPHIBEDGEW=0 DPHIBEDGELW=0 NSUBEDGEO=5e+23 NSUBEDGEL=0 NSUBEDGELEXP=1 NSUBEDGEW=0 NSUBEDGELW=0 CTEDGEO=0 CTEDGEL=0 CTEDGELEXP=1 FBETEDGE=0 LPEDGE=1e-08 BETEDGEW=0 STBETEDGEO=1 STBETEDGEL=0 STBETEDGEW=0 STBETEDGELW=0 PSCEEDGEL=0 PSCEEDGELEXP=2 PSCEEDGEW=0 PSCEBEDGEO=0 PSCEDEDGEO=0 CFEDGEL=0 CFEDGELEXP=2 CFEDGEW=0 CFDEDGEO=0 CFBEDGEO=0 FNTEDGEO=1 NFAEDGELW=8e+22 NFBEDGELW=30000000 NFCEDGELW=0 EFEDGEO=1 SAREF=1e-06 SBREF=1e-06 WLOD=0 KUO=0 KVSAT=0 TKUO=0 LKUO=0 WKUO=0 PKUO=0 LLODKUO=0 WLODKUO=0 KVTHO=0 LKVTHO=0 WKVTHO=0 PKVTHO=0 LLODVTH=0 WLODVTH=0 STETAO=0 LODETAO=1 SCREF=1e-06 WEB=0 WEC=0 KVTHOWEO=0 KVTHOWEL=0 KVTHOWEW=0 KVTHOWELW=0 KUOWEO=0 KUOWEL=0 KUOWEW=0 KUOWELW=0 TRJ=21 SWJUNEXP=0 IMAX=0.0020128 FREV=1000 CJORBOT=0.00085856 CJORSTI=2.4557e-11 CJORGAT=1.3846e-11 VBIRBOT=0.74373 VBIRSTI=1.597 VBIRGAT=0.6629 PBOT=0.27424 PSTI=0.16571 PGAT=0.1451 CJORBOTD=0.001 CJORSTID=1e-09 CJORGATD=1e-09 VBIRBOTD=1 VBIRSTID=1 VBIRGATD=1 PBOTD=0.5 PSTID=0.5 PGATD=0.5 PHIGBOT=1.1984 PHIGSTI=1.006 PHIGGAT=0.3 IDSATRBOT=5.397e-08 IDSATRSTI=4.0612e-15 IDSATRGAT=0 CSRHBOT=100 CSRHSTI=0.0001 CSRHGAT=0.0001 XJUNSTI=1.61e-08 XJUNGAT=6.134e-07 PHIGBOTD=1.16 PHIGSTID=1.16 PHIGGATD=1.16 IDSATRBOTD=1e-12 IDSATRSTID=1e-18 IDSATRGATD=1e-18 CSRHBOTD=100 CSRHSTID=0.0001 CSRHGATD=0.0001 XJUNSTID=1e-07 XJUNGATD=1e-07 CTATBOT=100 CTATSTI=0.0001 CTATGAT=0.0001 MEFFTATBOT=0.25 MEFFTATSTI=0.25 MEFFTATGAT=0.25 CTATBOTD=100 CTATSTID=0.0001 CTATGATD=0.0001 MEFFTATBOTD=0.25 MEFFTATSTID=0.25 MEFFTATGATD=0.25 CBBTBOT=1e-12 CBBTSTI=1e-21 CBBTGAT=1e-18 FBBTRBOT=1000000000 FBBTRSTI=1000000000 FBBTRGAT=1000000000 STFBBTBOT=-0.001 STFBBTSTI=-0.001 STFBBTGAT=-0.001 CBBTBOTD=1e-12 CBBTSTID=1e-18 CBBTGATD=1e-18 FBBTRBOTD=1000000000 FBBTRSTID=1000000000 FBBTRGATD=1000000000 STFBBTBOTD=-0.001 STFBBTSTID=-0.001 STFBBTGATD=-0.001 VBRBOT=10 VBRSTI=10 VBRGAT=10 PBRBOT=4 PBRSTI=4 PBRGAT=4 VBRBOTD=10 VBRSTID=10 VBRGATD=10 PBRBOTD=4 PBRSTID=4 PBRGATD=4 VJUNREF=2.5 FJUNQ=0.03 VJUNREFD=2.5 FJUNQD=0.03 RINT=3.0856e-12 RVPOLY=0 DLSIL=0 RSH=0 RSHD=0 CFRW=6e-17 RSHG=20 RGO=35 RBULKO=234.5984 RWELLO=234.5984 RJUNSO=131.9616 RJUNDO=131.9616 SWSOA=0 VGS_MAX=3 VGD_MAX=3 VGB_MAX=3 VDS_MAX=3 VDB_MAX=1.6 VSB_MAX=1.6
model hvn_w17264n_l2000n_ng2 PSP103VA TYPE=1 TR=27 DTA=0 SWGEO=1 SWIGATE=1 SWIMPACT=1 SWGIDL=0 SWJUNCAP=3 SWJUNASYM=0 SWNUD=0 SWEDGE=0 SWDELVTAC=0 SWIGN=1 QMC=1 LVARO=3.499e-08 LVARL=-0.09125 LVARW=0 LAP=6.3866e-08 WVARO=0 WVARL=0 WVARW=0 WOT=3e-08 DLQ=5.2202e-08 DWQ=3e-08 VFBO=-0.89839 VFBL=0.15096 VFBW=0.0017033 VFBLW=0.019398 STVFBO=0.0008739 STVFBL=0.00014864 STVFBW=-4.6174e-05 STVFBLW=-2.445e-06 ST2VFBO=0 TOXO=7.4256e-09 EPSROXO=3.9 NSUBO=1.8552e+23 NSUBW=-0.0050198 WSEG=1.098e-10 NPCK=3.178e+23 NPCKW=-2.7604 WSEGP=1e-08 LPCK=1e-08 LPCKW=0 FOL1=0.21033 FOL2=0.0026472 FACNEFFACO=1 FACNEFFACL=0 FACNEFFACW=0 FACNEFFACLW=0 GFACNUDO=1 GFACNUDL=0 GFACNUDLEXP=1 GFACNUDW=0 GFACNUDLW=0 VSBNUDO=0 DVSBNUDO=1 VNSUBO=0 NSLPO=0.05 DNSUBO=0.025686 DPHIBO=-0.0607576464 DPHIBL=-0.00546403785 DPHIBLEXP=2.3956 DPHIBW=0.014614 DPHIBLW=-0.017476272 DELVTACO=0 DELVTACL=0 DELVTACLEXP=1 DELVTACW=0 DELVTACLW=0 NPO=3.897e+26 NPL=-0.1215 TOXOVO=7.4256e-09 TOXOVDO=2e-09 LOV=6.3866e-08 LOVD=0 NOVO=5.5814e+24 NOVDO=5e+25 CTO=-0.061658 CTL=0.025 CTLEXP=1.6063 CTW=-0.044911 CTLW=-0.0077386 CTGO=0 CTBO=0 STCTO=1 CFL=0.0048288 CFLEXP=1.3328 CFW=0.037319 CFBO=0.26069 CFDO=0 PSCEL=0 PSCELEXP=2 PSCEW=0 PSCEBO=0 PSCEDO=0 UO=0.046687 FBET1=-0.35712 FBET1W=-0.14995 LP1=4.5615e-08 LP1W=0.4189 FBET2=-1.0245 LP2=9.42e-09 BETW1=0.6567 BETW2=-0.083639 WBET=1.0063e-10 STBETO=1.6942 STBETL=-0.0065587 STBETW=-0.060053 STBETLW=0.00036994 MUEO=0.91692524 MUEW=-0.018226 STMUEO=0.34067 THEMUO=2.5509 STTHEMUO=0.63756 CSO=2.0494 CSL=-0.97261 CSLEXP=0 CSW=0.044205 CSLW=-1.0021 STCSO=2.5545 THECSO=2 STTHECSO=0 XCORO=0.04872 XCORL=-0.27137 XCORW=-0.1948 XCORLW=0 STXCORO=1.1327 FETAO=1.0706 RSW1=321.598966 RSW2=-0.07 STRSO=-0.058157 RSBO=-0.0025425 RSGO=0.10986 THESATO=0.1 THESATL=0.446499 THESATLEXP=1.0973 THESATW=0.082797 THESATLW=-0.032897685 STTHESATO=0.48396 STTHESATL=0.50226 STTHESATW=0.049985 STTHESATLW=-0.059487 THESATBO=0.06 THESATGO=0.050814 AXO=8.7694 AXL=2.3029 ALPL=0.0019702 ALPLEXP=1.4003 ALPW=1.1052 ALP1L1=0.007475 ALP1LEXP=0.80983 ALP1L2=0.719 ALP1W=0.56703 ALP2L1=5.413e-07 ALP2LEXP=0.2541 ALP2L2=0 ALP2W=-10 VPO=0.06567 A1O=4.7288 A1L=0.052459 A1W=0.024056 A2O=22.013 STA2O=0.018532 A3O=1.2047 A3L=-0.10308 A3W=0.0069117 A4O=0.12894 A4L=-0.05413 A4W=-0.06197 GCOO=0 IGINVLW=0 IGOVW=0 IGOVDW=0 STIGO=2 GC2O=0.375 GC3O=0.063 CHIBO=3.1 AGIDLW=70 AGIDLDW=0 BGIDLO=13 BGIDLDO=41 STBGIDLO=-0.001067 STBGIDLDO=0 CGIDLO=0 CGIDLDO=0 CGBOVL=2.522e-16 CFRDW=0 FNTO=1 FNTEXCL=0 NFALW=1.42e+25 NFBLW=574300000 NFCLW=-3.015e-08 EFO=1 LINTNOI=-3.158e-08 ALPNOI=2.708 WEDGE=1e-08 WEDGEW=0 VFBEDGEO=-1 STVFBEDGEO=0.0005 STVFBEDGEL=0 STVFBEDGEW=0 STVFBEDGELW=0 DPHIBEDGEO=0 DPHIBEDGEL=0 DPHIBEDGELEXP=1 DPHIBEDGEW=0 DPHIBEDGELW=0 NSUBEDGEO=5e+23 NSUBEDGEL=0 NSUBEDGELEXP=1 NSUBEDGEW=0 NSUBEDGELW=0 CTEDGEO=0 CTEDGEL=0 CTEDGELEXP=1 FBETEDGE=0 LPEDGE=1e-08 BETEDGEW=0 STBETEDGEO=1 STBETEDGEL=0 STBETEDGEW=0 STBETEDGELW=0 PSCEEDGEL=0 PSCEEDGELEXP=2 PSCEEDGEW=0 PSCEBEDGEO=0 PSCEDEDGEO=0 CFEDGEL=0 CFEDGELEXP=2 CFEDGEW=0 CFDEDGEO=0 CFBEDGEO=0 FNTEDGEO=1 NFAEDGELW=8e+22 NFBEDGELW=30000000 NFCEDGELW=0 EFEDGEO=1 SAREF=1e-06 SBREF=1e-06 WLOD=0 KUO=0 KVSAT=0 TKUO=0 LKUO=0 WKUO=0 PKUO=0 LLODKUO=0 WLODKUO=0 KVTHO=0 LKVTHO=0 WKVTHO=0 PKVTHO=0 LLODVTH=0 WLODVTH=0 STETAO=0 LODETAO=1 SCREF=1e-06 WEB=0 WEC=0 KVTHOWEO=0 KVTHOWEL=0 KVTHOWEW=0 KVTHOWELW=0 KUOWEO=0 KUOWEL=0 KUOWEW=0 KUOWELW=0 TRJ=21 SWJUNEXP=0 IMAX=0.0020128 FREV=1000 CJORBOT=0.00085856 CJORSTI=2.4557e-11 CJORGAT=1.3846e-11 VBIRBOT=0.74373 VBIRSTI=1.597 VBIRGAT=0.6629 PBOT=0.27424 PSTI=0.16571 PGAT=0.1451 CJORBOTD=0.001 CJORSTID=1e-09 CJORGATD=1e-09 VBIRBOTD=1 VBIRSTID=1 VBIRGATD=1 PBOTD=0.5 PSTID=0.5 PGATD=0.5 PHIGBOT=1.1984 PHIGSTI=1.006 PHIGGAT=0.3 IDSATRBOT=5.397e-08 IDSATRSTI=4.0612e-15 IDSATRGAT=0 CSRHBOT=100 CSRHSTI=0.0001 CSRHGAT=0.0001 XJUNSTI=1.61e-08 XJUNGAT=6.134e-07 PHIGBOTD=1.16 PHIGSTID=1.16 PHIGGATD=1.16 IDSATRBOTD=1e-12 IDSATRSTID=1e-18 IDSATRGATD=1e-18 CSRHBOTD=100 CSRHSTID=0.0001 CSRHGATD=0.0001 XJUNSTID=1e-07 XJUNGATD=1e-07 CTATBOT=100 CTATSTI=0.0001 CTATGAT=0.0001 MEFFTATBOT=0.25 MEFFTATSTI=0.25 MEFFTATGAT=0.25 CTATBOTD=100 CTATSTID=0.0001 CTATGATD=0.0001 MEFFTATBOTD=0.25 MEFFTATSTID=0.25 MEFFTATGATD=0.25 CBBTBOT=1e-12 CBBTSTI=1e-21 CBBTGAT=1e-18 FBBTRBOT=1000000000 FBBTRSTI=1000000000 FBBTRGAT=1000000000 STFBBTBOT=-0.001 STFBBTSTI=-0.001 STFBBTGAT=-0.001 CBBTBOTD=1e-12 CBBTSTID=1e-18 CBBTGATD=1e-18 FBBTRBOTD=1000000000 FBBTRSTID=1000000000 FBBTRGATD=1000000000 STFBBTBOTD=-0.001 STFBBTSTID=-0.001 STFBBTGATD=-0.001 VBRBOT=10 VBRSTI=10 VBRGAT=10 PBRBOT=4 PBRSTI=4 PBRGAT=4 VBRBOTD=10 VBRSTID=10 VBRGATD=10 PBRBOTD=4 PBRSTID=4 PBRGATD=4 VJUNREF=2.5 FJUNQ=0.03 VJUNREFD=2.5 FJUNQD=0.03 RINT=3.0856e-12 RVPOLY=0 DLSIL=0 RSH=0 RSHD=0 CFRW=6e-17 RSHG=20 RGO=35 RBULKO=231.7021235 RWELLO=231.7021235 RJUNSO=579.2553086 RJUNDO=579.2553086 SWSOA=0 VGS_MAX=3 VGD_MAX=3 VGB_MAX=3 VDS_MAX=3 VDB_MAX=1.6 VSB_MAX=1.6
model hvn_w2000n_l1000n_ng1 PSP103VA TYPE=1 TR=27 DTA=0 SWGEO=1 SWIGATE=1 SWIMPACT=1 SWGIDL=0 SWJUNCAP=3 SWJUNASYM=0 SWNUD=0 SWEDGE=0 SWDELVTAC=0 SWIGN=1 QMC=1 LVARO=3.499e-08 LVARL=-0.09125 LVARW=0 LAP=6.3866e-08 WVARO=0 WVARL=0 WVARW=0 WOT=3e-08 DLQ=5.2202e-08 DWQ=3e-08 VFBO=-0.89839 VFBL=0.15096 VFBW=0.0017033 VFBLW=0.019398 STVFBO=0.0008739 STVFBL=0.00014864 STVFBW=-4.6174e-05 STVFBLW=-2.445e-06 ST2VFBO=0 TOXO=7.4256e-09 EPSROXO=3.9 NSUBO=1.8552e+23 NSUBW=-0.0050198 WSEG=1.098e-10 NPCK=3.178e+23 NPCKW=-2.7604 WSEGP=1e-08 LPCK=1e-08 LPCKW=0 FOL1=0.21033 FOL2=0.0026472 FACNEFFACO=1 FACNEFFACL=0 FACNEFFACW=0 FACNEFFACLW=0 GFACNUDO=1 GFACNUDL=0 GFACNUDLEXP=1 GFACNUDW=0 GFACNUDLW=0 VSBNUDO=0 DVSBNUDO=1 VNSUBO=0 NSLPO=0.05 DNSUBO=0.025686 DPHIBO=-0.0607576464 DPHIBL=-0.00546403785 DPHIBLEXP=2.3956 DPHIBW=0.014614 DPHIBLW=-0.017476272 DELVTACO=0 DELVTACL=0 DELVTACLEXP=1 DELVTACW=0 DELVTACLW=0 NPO=3.897e+26 NPL=-0.1215 TOXOVO=7.4256e-09 TOXOVDO=2e-09 LOV=6.3866e-08 LOVD=0 NOVO=5.5814e+24 NOVDO=5e+25 CTO=-0.061658 CTL=0.025 CTLEXP=1.6063 CTW=-0.044911 CTLW=-0.0077386 CTGO=0 CTBO=0 STCTO=1 CFL=0.0048288 CFLEXP=1.3328 CFW=0.037319 CFBO=0.26069 CFDO=0 PSCEL=0 PSCELEXP=2 PSCEW=0 PSCEBO=0 PSCEDO=0 UO=0.046687 FBET1=-0.35712 FBET1W=-0.14995 LP1=4.5615e-08 LP1W=0.4189 FBET2=-1.0245 LP2=9.42e-09 BETW1=0.6567 BETW2=-0.083639 WBET=1.0063e-10 STBETO=1.6942 STBETL=-0.0065587 STBETW=-0.060053 STBETLW=0.00036994 MUEO=0.91692524 MUEW=-0.018226 STMUEO=0.34067 THEMUO=2.5509 STTHEMUO=0.63756 CSO=2.0494 CSL=-0.97261 CSLEXP=0 CSW=0.044205 CSLW=-1.0021 STCSO=2.5545 THECSO=2 STTHECSO=0 XCORO=0.04872 XCORL=-0.27137 XCORW=-0.1948 XCORLW=0 STXCORO=1.1327 FETAO=1.0706 RSW1=321.598966 RSW2=-0.07 STRSO=-0.058157 RSBO=-0.0025425 RSGO=0.10986 THESATO=0.1 THESATL=0.446499 THESATLEXP=1.0973 THESATW=0.082797 THESATLW=-0.032897685 STTHESATO=0.48396 STTHESATL=0.50226 STTHESATW=0.049985 STTHESATLW=-0.059487 THESATBO=0.06 THESATGO=0.050814 AXO=8.7694 AXL=2.3029 ALPL=0.0019702 ALPLEXP=1.4003 ALPW=1.1052 ALP1L1=0.007475 ALP1LEXP=0.80983 ALP1L2=0.719 ALP1W=0.56703 ALP2L1=5.413e-07 ALP2LEXP=0.2541 ALP2L2=0 ALP2W=-10 VPO=0.06567 A1O=4.7288 A1L=0.052459 A1W=0.024056 A2O=22.013 STA2O=0.018532 A3O=1.2047 A3L=-0.10308 A3W=0.0069117 A4O=0.12894 A4L=-0.05413 A4W=-0.06197 GCOO=0 IGINVLW=0 IGOVW=0 IGOVDW=0 STIGO=2 GC2O=0.375 GC3O=0.063 CHIBO=3.1 AGIDLW=70 AGIDLDW=0 BGIDLO=13 BGIDLDO=41 STBGIDLO=-0.001067 STBGIDLDO=0 CGIDLO=0 CGIDLDO=0 CGBOVL=2.522e-16 CFRDW=0 FNTO=1 FNTEXCL=0 NFALW=1.42e+25 NFBLW=574300000 NFCLW=-3.015e-08 EFO=1 LINTNOI=-3.158e-08 ALPNOI=2.708 WEDGE=1e-08 WEDGEW=0 VFBEDGEO=-1 STVFBEDGEO=0.0005 STVFBEDGEL=0 STVFBEDGEW=0 STVFBEDGELW=0 DPHIBEDGEO=0 DPHIBEDGEL=0 DPHIBEDGELEXP=1 DPHIBEDGEW=0 DPHIBEDGELW=0 NSUBEDGEO=5e+23 NSUBEDGEL=0 NSUBEDGELEXP=1 NSUBEDGEW=0 NSUBEDGELW=0 CTEDGEO=0 CTEDGEL=0 CTEDGELEXP=1 FBETEDGE=0 LPEDGE=1e-08 BETEDGEW=0 STBETEDGEO=1 STBETEDGEL=0 STBETEDGEW=0 STBETEDGELW=0 PSCEEDGEL=0 PSCEEDGELEXP=2 PSCEEDGEW=0 PSCEBEDGEO=0 PSCEDEDGEO=0 CFEDGEL=0 CFEDGELEXP=2 CFEDGEW=0 CFDEDGEO=0 CFBEDGEO=0 FNTEDGEO=1 NFAEDGELW=8e+22 NFBEDGELW=30000000 NFCEDGELW=0 EFEDGEO=1 SAREF=1e-06 SBREF=1e-06 WLOD=0 KUO=0 KVSAT=0 TKUO=0 LKUO=0 WKUO=0 PKUO=0 LLODKUO=0 WLODKUO=0 KVTHO=0 LKVTHO=0 WKVTHO=0 PKVTHO=0 LLODVTH=0 WLODVTH=0 STETAO=0 LODETAO=1 SCREF=1e-06 WEB=0 WEC=0 KVTHOWEO=0 KVTHOWEL=0 KVTHOWEW=0 KVTHOWELW=0 KUOWEO=0 KUOWEL=0 KUOWEW=0 KUOWELW=0 TRJ=21 SWJUNEXP=0 IMAX=0.0020128 FREV=1000 CJORBOT=0.00085856 CJORSTI=2.4557e-11 CJORGAT=1.3846e-11 VBIRBOT=0.74373 VBIRSTI=1.597 VBIRGAT=0.6629 PBOT=0.27424 PSTI=0.16571 PGAT=0.1451 CJORBOTD=0.001 CJORSTID=1e-09 CJORGATD=1e-09 VBIRBOTD=1 VBIRSTID=1 VBIRGATD=1 PBOTD=0.5 PSTID=0.5 PGATD=0.5 PHIGBOT=1.1984 PHIGSTI=1.006 PHIGGAT=0.3 IDSATRBOT=5.397e-08 IDSATRSTI=4.0612e-15 IDSATRGAT=0 CSRHBOT=100 CSRHSTI=0.0001 CSRHGAT=0.0001 XJUNSTI=1.61e-08 XJUNGAT=6.134e-07 PHIGBOTD=1.16 PHIGSTID=1.16 PHIGGATD=1.16 IDSATRBOTD=1e-12 IDSATRSTID=1e-18 IDSATRGATD=1e-18 CSRHBOTD=100 CSRHSTID=0.0001 CSRHGATD=0.0001 XJUNSTID=1e-07 XJUNGATD=1e-07 CTATBOT=100 CTATSTI=0.0001 CTATGAT=0.0001 MEFFTATBOT=0.25 MEFFTATSTI=0.25 MEFFTATGAT=0.25 CTATBOTD=100 CTATSTID=0.0001 CTATGATD=0.0001 MEFFTATBOTD=0.25 MEFFTATSTID=0.25 MEFFTATGATD=0.25 CBBTBOT=1e-12 CBBTSTI=1e-21 CBBTGAT=1e-18 FBBTRBOT=1000000000 FBBTRSTI=1000000000 FBBTRGAT=1000000000 STFBBTBOT=-0.001 STFBBTSTI=-0.001 STFBBTGAT=-0.001 CBBTBOTD=1e-12 CBBTSTID=1e-18 CBBTGATD=1e-18 FBBTRBOTD=1000000000 FBBTRSTID=1000000000 FBBTRGATD=1000000000 STFBBTBOTD=-0.001 STFBBTSTID=-0.001 STFBBTGATD=-0.001 VBRBOT=10 VBRSTI=10 VBRGAT=10 PBRBOT=4 PBRSTI=4 PBRGAT=4 VBRBOTD=10 VBRSTID=10 VBRGATD=10 PBRBOTD=4 PBRSTID=4 PBRGATD=4 VJUNREF=2.5 FJUNQ=0.03 VJUNREFD=2.5 FJUNQD=0.03 RINT=3.0856e-12 RVPOLY=0 DLSIL=0 RSH=0 RSHD=0 CFRW=1.2e-16 RSHG=20 RGO=35 RBULKO=1000 RWELLO=1000 RJUNSO=2500 RJUNDO=2500 SWSOA=0 VGS_MAX=3 VGD_MAX=3 VGB_MAX=3 VDS_MAX=3 VDB_MAX=1.6 VSB_MAX=1.6
model hvn_w2000n_l450n_ng1 PSP103VA TYPE=1 TR=27 DTA=0 SWGEO=1 SWIGATE=1 SWIMPACT=1 SWGIDL=0 SWJUNCAP=3 SWJUNASYM=0 SWNUD=0 SWEDGE=0 SWDELVTAC=0 SWIGN=1 QMC=1 LVARO=3.499e-08 LVARL=-0.09125 LVARW=0 LAP=6.3866e-08 WVARO=0 WVARL=0 WVARW=0 WOT=3e-08 DLQ=5.2202e-08 DWQ=3e-08 VFBO=-0.89839 VFBL=0.15096 VFBW=0.0017033 VFBLW=0.019398 STVFBO=0.0008739 STVFBL=0.00014864 STVFBW=-4.6174e-05 STVFBLW=-2.445e-06 ST2VFBO=0 TOXO=7.4256e-09 EPSROXO=3.9 NSUBO=1.8552e+23 NSUBW=-0.0050198 WSEG=1.098e-10 NPCK=3.178e+23 NPCKW=-2.7604 WSEGP=1e-08 LPCK=1e-08 LPCKW=0 FOL1=0.21033 FOL2=0.0026472 FACNEFFACO=1 FACNEFFACL=0 FACNEFFACW=0 FACNEFFACLW=0 GFACNUDO=1 GFACNUDL=0 GFACNUDLEXP=1 GFACNUDW=0 GFACNUDLW=0 VSBNUDO=0 DVSBNUDO=1 VNSUBO=0 NSLPO=0.05 DNSUBO=0.025686 DPHIBO=-0.0607576464 DPHIBL=-0.00546403785 DPHIBLEXP=2.3956 DPHIBW=0.014614 DPHIBLW=-0.017476272 DELVTACO=0 DELVTACL=0 DELVTACLEXP=1 DELVTACW=0 DELVTACLW=0 NPO=3.897e+26 NPL=-0.1215 TOXOVO=7.4256e-09 TOXOVDO=2e-09 LOV=6.3866e-08 LOVD=0 NOVO=5.5814e+24 NOVDO=5e+25 CTO=-0.061658 CTL=0.025 CTLEXP=1.6063 CTW=-0.044911 CTLW=-0.0077386 CTGO=0 CTBO=0 STCTO=1 CFL=0.0048288 CFLEXP=1.3328 CFW=0.037319 CFBO=0.26069 CFDO=0 PSCEL=0 PSCELEXP=2 PSCEW=0 PSCEBO=0 PSCEDO=0 UO=0.046687 FBET1=-0.35712 FBET1W=-0.14995 LP1=4.5615e-08 LP1W=0.4189 FBET2=-1.0245 LP2=9.42e-09 BETW1=0.6567 BETW2=-0.083639 WBET=1.0063e-10 STBETO=1.6942 STBETL=-0.0065587 STBETW=-0.060053 STBETLW=0.00036994 MUEO=0.91692524 MUEW=-0.018226 STMUEO=0.34067 THEMUO=2.5509 STTHEMUO=0.63756 CSO=2.0494 CSL=-0.97261 CSLEXP=0 CSW=0.044205 CSLW=-1.0021 STCSO=2.5545 THECSO=2 STTHECSO=0 XCORO=0.04872 XCORL=-0.27137 XCORW=-0.1948 XCORLW=0 STXCORO=1.1327 FETAO=1.0706 RSW1=321.598966 RSW2=-0.07 STRSO=-0.058157 RSBO=-0.0025425 RSGO=0.10986 THESATO=0.1 THESATL=0.446499 THESATLEXP=1.0973 THESATW=0.082797 THESATLW=-0.032897685 STTHESATO=0.48396 STTHESATL=0.50226 STTHESATW=0.049985 STTHESATLW=-0.059487 THESATBO=0.06 THESATGO=0.050814 AXO=8.7694 AXL=2.3029 ALPL=0.0019702 ALPLEXP=1.4003 ALPW=1.1052 ALP1L1=0.007475 ALP1LEXP=0.80983 ALP1L2=0.719 ALP1W=0.56703 ALP2L1=5.413e-07 ALP2LEXP=0.2541 ALP2L2=0 ALP2W=-10 VPO=0.06567 A1O=4.7288 A1L=0.052459 A1W=0.024056 A2O=22.013 STA2O=0.018532 A3O=1.2047 A3L=-0.10308 A3W=0.0069117 A4O=0.12894 A4L=-0.05413 A4W=-0.06197 GCOO=0 IGINVLW=0 IGOVW=0 IGOVDW=0 STIGO=2 GC2O=0.375 GC3O=0.063 CHIBO=3.1 AGIDLW=70 AGIDLDW=0 BGIDLO=13 BGIDLDO=41 STBGIDLO=-0.001067 STBGIDLDO=0 CGIDLO=0 CGIDLDO=0 CGBOVL=2.522e-16 CFRDW=0 FNTO=1 FNTEXCL=0 NFALW=1.42e+25 NFBLW=574300000 NFCLW=-3.015e-08 EFO=1 LINTNOI=-3.158e-08 ALPNOI=2.708 WEDGE=1e-08 WEDGEW=0 VFBEDGEO=-1 STVFBEDGEO=0.0005 STVFBEDGEL=0 STVFBEDGEW=0 STVFBEDGELW=0 DPHIBEDGEO=0 DPHIBEDGEL=0 DPHIBEDGELEXP=1 DPHIBEDGEW=0 DPHIBEDGELW=0 NSUBEDGEO=5e+23 NSUBEDGEL=0 NSUBEDGELEXP=1 NSUBEDGEW=0 NSUBEDGELW=0 CTEDGEO=0 CTEDGEL=0 CTEDGELEXP=1 FBETEDGE=0 LPEDGE=1e-08 BETEDGEW=0 STBETEDGEO=1 STBETEDGEL=0 STBETEDGEW=0 STBETEDGELW=0 PSCEEDGEL=0 PSCEEDGELEXP=2 PSCEEDGEW=0 PSCEBEDGEO=0 PSCEDEDGEO=0 CFEDGEL=0 CFEDGELEXP=2 CFEDGEW=0 CFDEDGEO=0 CFBEDGEO=0 FNTEDGEO=1 NFAEDGELW=8e+22 NFBEDGELW=30000000 NFCEDGELW=0 EFEDGEO=1 SAREF=1e-06 SBREF=1e-06 WLOD=0 KUO=0 KVSAT=0 TKUO=0 LKUO=0 WKUO=0 PKUO=0 LLODKUO=0 WLODKUO=0 KVTHO=0 LKVTHO=0 WKVTHO=0 PKVTHO=0 LLODVTH=0 WLODVTH=0 STETAO=0 LODETAO=1 SCREF=1e-06 WEB=0 WEC=0 KVTHOWEO=0 KVTHOWEL=0 KVTHOWEW=0 KVTHOWELW=0 KUOWEO=0 KUOWEL=0 KUOWEW=0 KUOWELW=0 TRJ=21 SWJUNEXP=0 IMAX=0.0020128 FREV=1000 CJORBOT=0.00085856 CJORSTI=2.4557e-11 CJORGAT=1.3846e-11 VBIRBOT=0.74373 VBIRSTI=1.597 VBIRGAT=0.6629 PBOT=0.27424 PSTI=0.16571 PGAT=0.1451 CJORBOTD=0.001 CJORSTID=1e-09 CJORGATD=1e-09 VBIRBOTD=1 VBIRSTID=1 VBIRGATD=1 PBOTD=0.5 PSTID=0.5 PGATD=0.5 PHIGBOT=1.1984 PHIGSTI=1.006 PHIGGAT=0.3 IDSATRBOT=5.397e-08 IDSATRSTI=4.0612e-15 IDSATRGAT=0 CSRHBOT=100 CSRHSTI=0.0001 CSRHGAT=0.0001 XJUNSTI=1.61e-08 XJUNGAT=6.134e-07 PHIGBOTD=1.16 PHIGSTID=1.16 PHIGGATD=1.16 IDSATRBOTD=1e-12 IDSATRSTID=1e-18 IDSATRGATD=1e-18 CSRHBOTD=100 CSRHSTID=0.0001 CSRHGATD=0.0001 XJUNSTID=1e-07 XJUNGATD=1e-07 CTATBOT=100 CTATSTI=0.0001 CTATGAT=0.0001 MEFFTATBOT=0.25 MEFFTATSTI=0.25 MEFFTATGAT=0.25 CTATBOTD=100 CTATSTID=0.0001 CTATGATD=0.0001 MEFFTATBOTD=0.25 MEFFTATSTID=0.25 MEFFTATGATD=0.25 CBBTBOT=1e-12 CBBTSTI=1e-21 CBBTGAT=1e-18 FBBTRBOT=1000000000 FBBTRSTI=1000000000 FBBTRGAT=1000000000 STFBBTBOT=-0.001 STFBBTSTI=-0.001 STFBBTGAT=-0.001 CBBTBOTD=1e-12 CBBTSTID=1e-18 CBBTGATD=1e-18 FBBTRBOTD=1000000000 FBBTRSTID=1000000000 FBBTRGATD=1000000000 STFBBTBOTD=-0.001 STFBBTSTID=-0.001 STFBBTGATD=-0.001 VBRBOT=10 VBRSTI=10 VBRGAT=10 PBRBOT=4 PBRSTI=4 PBRGAT=4 VBRBOTD=10 VBRSTID=10 VBRGATD=10 PBRBOTD=4 PBRSTID=4 PBRGATD=4 VJUNREF=2.5 FJUNQ=0.03 VJUNREFD=2.5 FJUNQD=0.03 RINT=3.0856e-12 RVPOLY=0 DLSIL=0 RSH=0 RSHD=0 CFRW=1.2e-16 RSHG=20 RGO=35 RBULKO=1000 RWELLO=1000 RJUNSO=1125 RJUNDO=1125 SWSOA=0 VGS_MAX=3 VGD_MAX=3 VGB_MAX=3 VDS_MAX=3 VDB_MAX=1.6 VSB_MAX=1.6
model hvn_w3446n_l450n_ng1 PSP103VA TYPE=1 TR=27 DTA=0 SWGEO=1 SWIGATE=1 SWIMPACT=1 SWGIDL=0 SWJUNCAP=3 SWJUNASYM=0 SWNUD=0 SWEDGE=0 SWDELVTAC=0 SWIGN=1 QMC=1 LVARO=3.499e-08 LVARL=-0.09125 LVARW=0 LAP=6.3866e-08 WVARO=0 WVARL=0 WVARW=0 WOT=3e-08 DLQ=5.2202e-08 DWQ=3e-08 VFBO=-0.89839 VFBL=0.15096 VFBW=0.0017033 VFBLW=0.019398 STVFBO=0.0008739 STVFBL=0.00014864 STVFBW=-4.6174e-05 STVFBLW=-2.445e-06 ST2VFBO=0 TOXO=7.4256e-09 EPSROXO=3.9 NSUBO=1.8552e+23 NSUBW=-0.0050198 WSEG=1.098e-10 NPCK=3.178e+23 NPCKW=-2.7604 WSEGP=1e-08 LPCK=1e-08 LPCKW=0 FOL1=0.21033 FOL2=0.0026472 FACNEFFACO=1 FACNEFFACL=0 FACNEFFACW=0 FACNEFFACLW=0 GFACNUDO=1 GFACNUDL=0 GFACNUDLEXP=1 GFACNUDW=0 GFACNUDLW=0 VSBNUDO=0 DVSBNUDO=1 VNSUBO=0 NSLPO=0.05 DNSUBO=0.025686 DPHIBO=-0.0607576464 DPHIBL=-0.00546403785 DPHIBLEXP=2.3956 DPHIBW=0.014614 DPHIBLW=-0.017476272 DELVTACO=0 DELVTACL=0 DELVTACLEXP=1 DELVTACW=0 DELVTACLW=0 NPO=3.897e+26 NPL=-0.1215 TOXOVO=7.4256e-09 TOXOVDO=2e-09 LOV=6.3866e-08 LOVD=0 NOVO=5.5814e+24 NOVDO=5e+25 CTO=-0.061658 CTL=0.025 CTLEXP=1.6063 CTW=-0.044911 CTLW=-0.0077386 CTGO=0 CTBO=0 STCTO=1 CFL=0.0048288 CFLEXP=1.3328 CFW=0.037319 CFBO=0.26069 CFDO=0 PSCEL=0 PSCELEXP=2 PSCEW=0 PSCEBO=0 PSCEDO=0 UO=0.046687 FBET1=-0.35712 FBET1W=-0.14995 LP1=4.5615e-08 LP1W=0.4189 FBET2=-1.0245 LP2=9.42e-09 BETW1=0.6567 BETW2=-0.083639 WBET=1.0063e-10 STBETO=1.6942 STBETL=-0.0065587 STBETW=-0.060053 STBETLW=0.00036994 MUEO=0.91692524 MUEW=-0.018226 STMUEO=0.34067 THEMUO=2.5509 STTHEMUO=0.63756 CSO=2.0494 CSL=-0.97261 CSLEXP=0 CSW=0.044205 CSLW=-1.0021 STCSO=2.5545 THECSO=2 STTHECSO=0 XCORO=0.04872 XCORL=-0.27137 XCORW=-0.1948 XCORLW=0 STXCORO=1.1327 FETAO=1.0706 RSW1=321.598966 RSW2=-0.07 STRSO=-0.058157 RSBO=-0.0025425 RSGO=0.10986 THESATO=0.1 THESATL=0.446499 THESATLEXP=1.0973 THESATW=0.082797 THESATLW=-0.032897685 STTHESATO=0.48396 STTHESATL=0.50226 STTHESATW=0.049985 STTHESATLW=-0.059487 THESATBO=0.06 THESATGO=0.050814 AXO=8.7694 AXL=2.3029 ALPL=0.0019702 ALPLEXP=1.4003 ALPW=1.1052 ALP1L1=0.007475 ALP1LEXP=0.80983 ALP1L2=0.719 ALP1W=0.56703 ALP2L1=5.413e-07 ALP2LEXP=0.2541 ALP2L2=0 ALP2W=-10 VPO=0.06567 A1O=4.7288 A1L=0.052459 A1W=0.024056 A2O=22.013 STA2O=0.018532 A3O=1.2047 A3L=-0.10308 A3W=0.0069117 A4O=0.12894 A4L=-0.05413 A4W=-0.06197 GCOO=0 IGINVLW=0 IGOVW=0 IGOVDW=0 STIGO=2 GC2O=0.375 GC3O=0.063 CHIBO=3.1 AGIDLW=70 AGIDLDW=0 BGIDLO=13 BGIDLDO=41 STBGIDLO=-0.001067 STBGIDLDO=0 CGIDLO=0 CGIDLDO=0 CGBOVL=2.522e-16 CFRDW=0 FNTO=1 FNTEXCL=0 NFALW=1.42e+25 NFBLW=574300000 NFCLW=-3.015e-08 EFO=1 LINTNOI=-3.158e-08 ALPNOI=2.708 WEDGE=1e-08 WEDGEW=0 VFBEDGEO=-1 STVFBEDGEO=0.0005 STVFBEDGEL=0 STVFBEDGEW=0 STVFBEDGELW=0 DPHIBEDGEO=0 DPHIBEDGEL=0 DPHIBEDGELEXP=1 DPHIBEDGEW=0 DPHIBEDGELW=0 NSUBEDGEO=5e+23 NSUBEDGEL=0 NSUBEDGELEXP=1 NSUBEDGEW=0 NSUBEDGELW=0 CTEDGEO=0 CTEDGEL=0 CTEDGELEXP=1 FBETEDGE=0 LPEDGE=1e-08 BETEDGEW=0 STBETEDGEO=1 STBETEDGEL=0 STBETEDGEW=0 STBETEDGELW=0 PSCEEDGEL=0 PSCEEDGELEXP=2 PSCEEDGEW=0 PSCEBEDGEO=0 PSCEDEDGEO=0 CFEDGEL=0 CFEDGELEXP=2 CFEDGEW=0 CFDEDGEO=0 CFBEDGEO=0 FNTEDGEO=1 NFAEDGELW=8e+22 NFBEDGELW=30000000 NFCEDGELW=0 EFEDGEO=1 SAREF=1e-06 SBREF=1e-06 WLOD=0 KUO=0 KVSAT=0 TKUO=0 LKUO=0 WKUO=0 PKUO=0 LLODKUO=0 WLODKUO=0 KVTHO=0 LKVTHO=0 WKVTHO=0 PKVTHO=0 LLODVTH=0 WLODVTH=0 STETAO=0 LODETAO=1 SCREF=1e-06 WEB=0 WEC=0 KVTHOWEO=0 KVTHOWEL=0 KVTHOWEW=0 KVTHOWELW=0 KUOWEO=0 KUOWEL=0 KUOWEW=0 KUOWELW=0 TRJ=21 SWJUNEXP=0 IMAX=0.0020128 FREV=1000 CJORBOT=0.00085856 CJORSTI=2.4557e-11 CJORGAT=1.3846e-11 VBIRBOT=0.74373 VBIRSTI=1.597 VBIRGAT=0.6629 PBOT=0.27424 PSTI=0.16571 PGAT=0.1451 CJORBOTD=0.001 CJORSTID=1e-09 CJORGATD=1e-09 VBIRBOTD=1 VBIRSTID=1 VBIRGATD=1 PBOTD=0.5 PSTID=0.5 PGATD=0.5 PHIGBOT=1.1984 PHIGSTI=1.006 PHIGGAT=0.3 IDSATRBOT=5.397e-08 IDSATRSTI=4.0612e-15 IDSATRGAT=0 CSRHBOT=100 CSRHSTI=0.0001 CSRHGAT=0.0001 XJUNSTI=1.61e-08 XJUNGAT=6.134e-07 PHIGBOTD=1.16 PHIGSTID=1.16 PHIGGATD=1.16 IDSATRBOTD=1e-12 IDSATRSTID=1e-18 IDSATRGATD=1e-18 CSRHBOTD=100 CSRHSTID=0.0001 CSRHGATD=0.0001 XJUNSTID=1e-07 XJUNGATD=1e-07 CTATBOT=100 CTATSTI=0.0001 CTATGAT=0.0001 MEFFTATBOT=0.25 MEFFTATSTI=0.25 MEFFTATGAT=0.25 CTATBOTD=100 CTATSTID=0.0001 CTATGATD=0.0001 MEFFTATBOTD=0.25 MEFFTATSTID=0.25 MEFFTATGATD=0.25 CBBTBOT=1e-12 CBBTSTI=1e-21 CBBTGAT=1e-18 FBBTRBOT=1000000000 FBBTRSTI=1000000000 FBBTRGAT=1000000000 STFBBTBOT=-0.001 STFBBTSTI=-0.001 STFBBTGAT=-0.001 CBBTBOTD=1e-12 CBBTSTID=1e-18 CBBTGATD=1e-18 FBBTRBOTD=1000000000 FBBTRSTID=1000000000 FBBTRGATD=1000000000 STFBBTBOTD=-0.001 STFBBTSTID=-0.001 STFBBTGATD=-0.001 VBRBOT=10 VBRSTI=10 VBRGAT=10 PBRBOT=4 PBRSTI=4 PBRGAT=4 VBRBOTD=10 VBRSTID=10 VBRGATD=10 PBRBOTD=4 PBRSTID=4 PBRGATD=4 VJUNREF=2.5 FJUNQ=0.03 VJUNREFD=2.5 FJUNQD=0.03 RINT=3.0856e-12 RVPOLY=0 DLSIL=0 RSH=0 RSHD=0 CFRW=1.2e-16 RSHG=20 RGO=35 RBULKO=580.3845369 RWELLO=580.3845369 RJUNSO=652.932604 RJUNDO=652.932604 SWSOA=0 VGS_MAX=3 VGD_MAX=3 VGB_MAX=3 VDS_MAX=3 VDB_MAX=1.6 VSB_MAX=1.6
model hvn_w3625n_l450n_ng1 PSP103VA TYPE=1 TR=27 DTA=0 SWGEO=1 SWIGATE=1 SWIMPACT=1 SWGIDL=0 SWJUNCAP=3 SWJUNASYM=0 SWNUD=0 SWEDGE=0 SWDELVTAC=0 SWIGN=1 QMC=1 LVARO=3.499e-08 LVARL=-0.09125 LVARW=0 LAP=6.3866e-08 WVARO=0 WVARL=0 WVARW=0 WOT=3e-08 DLQ=5.2202e-08 DWQ=3e-08 VFBO=-0.89839 VFBL=0.15096 VFBW=0.0017033 VFBLW=0.019398 STVFBO=0.0008739 STVFBL=0.00014864 STVFBW=-4.6174e-05 STVFBLW=-2.445e-06 ST2VFBO=0 TOXO=7.4256e-09 EPSROXO=3.9 NSUBO=1.8552e+23 NSUBW=-0.0050198 WSEG=1.098e-10 NPCK=3.178e+23 NPCKW=-2.7604 WSEGP=1e-08 LPCK=1e-08 LPCKW=0 FOL1=0.21033 FOL2=0.0026472 FACNEFFACO=1 FACNEFFACL=0 FACNEFFACW=0 FACNEFFACLW=0 GFACNUDO=1 GFACNUDL=0 GFACNUDLEXP=1 GFACNUDW=0 GFACNUDLW=0 VSBNUDO=0 DVSBNUDO=1 VNSUBO=0 NSLPO=0.05 DNSUBO=0.025686 DPHIBO=-0.0607576464 DPHIBL=-0.00546403785 DPHIBLEXP=2.3956 DPHIBW=0.014614 DPHIBLW=-0.017476272 DELVTACO=0 DELVTACL=0 DELVTACLEXP=1 DELVTACW=0 DELVTACLW=0 NPO=3.897e+26 NPL=-0.1215 TOXOVO=7.4256e-09 TOXOVDO=2e-09 LOV=6.3866e-08 LOVD=0 NOVO=5.5814e+24 NOVDO=5e+25 CTO=-0.061658 CTL=0.025 CTLEXP=1.6063 CTW=-0.044911 CTLW=-0.0077386 CTGO=0 CTBO=0 STCTO=1 CFL=0.0048288 CFLEXP=1.3328 CFW=0.037319 CFBO=0.26069 CFDO=0 PSCEL=0 PSCELEXP=2 PSCEW=0 PSCEBO=0 PSCEDO=0 UO=0.046687 FBET1=-0.35712 FBET1W=-0.14995 LP1=4.5615e-08 LP1W=0.4189 FBET2=-1.0245 LP2=9.42e-09 BETW1=0.6567 BETW2=-0.083639 WBET=1.0063e-10 STBETO=1.6942 STBETL=-0.0065587 STBETW=-0.060053 STBETLW=0.00036994 MUEO=0.91692524 MUEW=-0.018226 STMUEO=0.34067 THEMUO=2.5509 STTHEMUO=0.63756 CSO=2.0494 CSL=-0.97261 CSLEXP=0 CSW=0.044205 CSLW=-1.0021 STCSO=2.5545 THECSO=2 STTHECSO=0 XCORO=0.04872 XCORL=-0.27137 XCORW=-0.1948 XCORLW=0 STXCORO=1.1327 FETAO=1.0706 RSW1=321.598966 RSW2=-0.07 STRSO=-0.058157 RSBO=-0.0025425 RSGO=0.10986 THESATO=0.1 THESATL=0.446499 THESATLEXP=1.0973 THESATW=0.082797 THESATLW=-0.032897685 STTHESATO=0.48396 STTHESATL=0.50226 STTHESATW=0.049985 STTHESATLW=-0.059487 THESATBO=0.06 THESATGO=0.050814 AXO=8.7694 AXL=2.3029 ALPL=0.0019702 ALPLEXP=1.4003 ALPW=1.1052 ALP1L1=0.007475 ALP1LEXP=0.80983 ALP1L2=0.719 ALP1W=0.56703 ALP2L1=5.413e-07 ALP2LEXP=0.2541 ALP2L2=0 ALP2W=-10 VPO=0.06567 A1O=4.7288 A1L=0.052459 A1W=0.024056 A2O=22.013 STA2O=0.018532 A3O=1.2047 A3L=-0.10308 A3W=0.0069117 A4O=0.12894 A4L=-0.05413 A4W=-0.06197 GCOO=0 IGINVLW=0 IGOVW=0 IGOVDW=0 STIGO=2 GC2O=0.375 GC3O=0.063 CHIBO=3.1 AGIDLW=70 AGIDLDW=0 BGIDLO=13 BGIDLDO=41 STBGIDLO=-0.001067 STBGIDLDO=0 CGIDLO=0 CGIDLDO=0 CGBOVL=2.522e-16 CFRDW=0 FNTO=1 FNTEXCL=0 NFALW=1.42e+25 NFBLW=574300000 NFCLW=-3.015e-08 EFO=1 LINTNOI=-3.158e-08 ALPNOI=2.708 WEDGE=1e-08 WEDGEW=0 VFBEDGEO=-1 STVFBEDGEO=0.0005 STVFBEDGEL=0 STVFBEDGEW=0 STVFBEDGELW=0 DPHIBEDGEO=0 DPHIBEDGEL=0 DPHIBEDGELEXP=1 DPHIBEDGEW=0 DPHIBEDGELW=0 NSUBEDGEO=5e+23 NSUBEDGEL=0 NSUBEDGELEXP=1 NSUBEDGEW=0 NSUBEDGELW=0 CTEDGEO=0 CTEDGEL=0 CTEDGELEXP=1 FBETEDGE=0 LPEDGE=1e-08 BETEDGEW=0 STBETEDGEO=1 STBETEDGEL=0 STBETEDGEW=0 STBETEDGELW=0 PSCEEDGEL=0 PSCEEDGELEXP=2 PSCEEDGEW=0 PSCEBEDGEO=0 PSCEDEDGEO=0 CFEDGEL=0 CFEDGELEXP=2 CFEDGEW=0 CFDEDGEO=0 CFBEDGEO=0 FNTEDGEO=1 NFAEDGELW=8e+22 NFBEDGELW=30000000 NFCEDGELW=0 EFEDGEO=1 SAREF=1e-06 SBREF=1e-06 WLOD=0 KUO=0 KVSAT=0 TKUO=0 LKUO=0 WKUO=0 PKUO=0 LLODKUO=0 WLODKUO=0 KVTHO=0 LKVTHO=0 WKVTHO=0 PKVTHO=0 LLODVTH=0 WLODVTH=0 STETAO=0 LODETAO=1 SCREF=1e-06 WEB=0 WEC=0 KVTHOWEO=0 KVTHOWEL=0 KVTHOWEW=0 KVTHOWELW=0 KUOWEO=0 KUOWEL=0 KUOWEW=0 KUOWELW=0 TRJ=21 SWJUNEXP=0 IMAX=0.0020128 FREV=1000 CJORBOT=0.00085856 CJORSTI=2.4557e-11 CJORGAT=1.3846e-11 VBIRBOT=0.74373 VBIRSTI=1.597 VBIRGAT=0.6629 PBOT=0.27424 PSTI=0.16571 PGAT=0.1451 CJORBOTD=0.001 CJORSTID=1e-09 CJORGATD=1e-09 VBIRBOTD=1 VBIRSTID=1 VBIRGATD=1 PBOTD=0.5 PSTID=0.5 PGATD=0.5 PHIGBOT=1.1984 PHIGSTI=1.006 PHIGGAT=0.3 IDSATRBOT=5.397e-08 IDSATRSTI=4.0612e-15 IDSATRGAT=0 CSRHBOT=100 CSRHSTI=0.0001 CSRHGAT=0.0001 XJUNSTI=1.61e-08 XJUNGAT=6.134e-07 PHIGBOTD=1.16 PHIGSTID=1.16 PHIGGATD=1.16 IDSATRBOTD=1e-12 IDSATRSTID=1e-18 IDSATRGATD=1e-18 CSRHBOTD=100 CSRHSTID=0.0001 CSRHGATD=0.0001 XJUNSTID=1e-07 XJUNGATD=1e-07 CTATBOT=100 CTATSTI=0.0001 CTATGAT=0.0001 MEFFTATBOT=0.25 MEFFTATSTI=0.25 MEFFTATGAT=0.25 CTATBOTD=100 CTATSTID=0.0001 CTATGATD=0.0001 MEFFTATBOTD=0.25 MEFFTATSTID=0.25 MEFFTATGATD=0.25 CBBTBOT=1e-12 CBBTSTI=1e-21 CBBTGAT=1e-18 FBBTRBOT=1000000000 FBBTRSTI=1000000000 FBBTRGAT=1000000000 STFBBTBOT=-0.001 STFBBTSTI=-0.001 STFBBTGAT=-0.001 CBBTBOTD=1e-12 CBBTSTID=1e-18 CBBTGATD=1e-18 FBBTRBOTD=1000000000 FBBTRSTID=1000000000 FBBTRGATD=1000000000 STFBBTBOTD=-0.001 STFBBTSTID=-0.001 STFBBTGATD=-0.001 VBRBOT=10 VBRSTI=10 VBRGAT=10 PBRBOT=4 PBRSTI=4 PBRGAT=4 VBRBOTD=10 VBRSTID=10 VBRGATD=10 PBRBOTD=4 PBRSTID=4 PBRGATD=4 VJUNREF=2.5 FJUNQ=0.03 VJUNREFD=2.5 FJUNQD=0.03 RINT=3.0856e-12 RVPOLY=0 DLSIL=0 RSH=0 RSHD=0 CFRW=1.2e-16 RSHG=20 RGO=35 RBULKO=551.6519655 RWELLO=551.6519655 RJUNSO=620.6084612 RJUNDO=620.6084612 SWSOA=0 VGS_MAX=3 VGD_MAX=3 VGB_MAX=3 VDS_MAX=3 VDB_MAX=1.6 VSB_MAX=1.6
model hvn_w3773n_l450n_ng1 PSP103VA TYPE=1 TR=27 DTA=0 SWGEO=1 SWIGATE=1 SWIMPACT=1 SWGIDL=0 SWJUNCAP=3 SWJUNASYM=0 SWNUD=0 SWEDGE=0 SWDELVTAC=0 SWIGN=1 QMC=1 LVARO=3.499e-08 LVARL=-0.09125 LVARW=0 LAP=6.3866e-08 WVARO=0 WVARL=0 WVARW=0 WOT=3e-08 DLQ=5.2202e-08 DWQ=3e-08 VFBO=-0.89839 VFBL=0.15096 VFBW=0.0017033 VFBLW=0.019398 STVFBO=0.0008739 STVFBL=0.00014864 STVFBW=-4.6174e-05 STVFBLW=-2.445e-06 ST2VFBO=0 TOXO=7.4256e-09 EPSROXO=3.9 NSUBO=1.8552e+23 NSUBW=-0.0050198 WSEG=1.098e-10 NPCK=3.178e+23 NPCKW=-2.7604 WSEGP=1e-08 LPCK=1e-08 LPCKW=0 FOL1=0.21033 FOL2=0.0026472 FACNEFFACO=1 FACNEFFACL=0 FACNEFFACW=0 FACNEFFACLW=0 GFACNUDO=1 GFACNUDL=0 GFACNUDLEXP=1 GFACNUDW=0 GFACNUDLW=0 VSBNUDO=0 DVSBNUDO=1 VNSUBO=0 NSLPO=0.05 DNSUBO=0.025686 DPHIBO=-0.0607576464 DPHIBL=-0.00546403785 DPHIBLEXP=2.3956 DPHIBW=0.014614 DPHIBLW=-0.017476272 DELVTACO=0 DELVTACL=0 DELVTACLEXP=1 DELVTACW=0 DELVTACLW=0 NPO=3.897e+26 NPL=-0.1215 TOXOVO=7.4256e-09 TOXOVDO=2e-09 LOV=6.3866e-08 LOVD=0 NOVO=5.5814e+24 NOVDO=5e+25 CTO=-0.061658 CTL=0.025 CTLEXP=1.6063 CTW=-0.044911 CTLW=-0.0077386 CTGO=0 CTBO=0 STCTO=1 CFL=0.0048288 CFLEXP=1.3328 CFW=0.037319 CFBO=0.26069 CFDO=0 PSCEL=0 PSCELEXP=2 PSCEW=0 PSCEBO=0 PSCEDO=0 UO=0.046687 FBET1=-0.35712 FBET1W=-0.14995 LP1=4.5615e-08 LP1W=0.4189 FBET2=-1.0245 LP2=9.42e-09 BETW1=0.6567 BETW2=-0.083639 WBET=1.0063e-10 STBETO=1.6942 STBETL=-0.0065587 STBETW=-0.060053 STBETLW=0.00036994 MUEO=0.91692524 MUEW=-0.018226 STMUEO=0.34067 THEMUO=2.5509 STTHEMUO=0.63756 CSO=2.0494 CSL=-0.97261 CSLEXP=0 CSW=0.044205 CSLW=-1.0021 STCSO=2.5545 THECSO=2 STTHECSO=0 XCORO=0.04872 XCORL=-0.27137 XCORW=-0.1948 XCORLW=0 STXCORO=1.1327 FETAO=1.0706 RSW1=321.598966 RSW2=-0.07 STRSO=-0.058157 RSBO=-0.0025425 RSGO=0.10986 THESATO=0.1 THESATL=0.446499 THESATLEXP=1.0973 THESATW=0.082797 THESATLW=-0.032897685 STTHESATO=0.48396 STTHESATL=0.50226 STTHESATW=0.049985 STTHESATLW=-0.059487 THESATBO=0.06 THESATGO=0.050814 AXO=8.7694 AXL=2.3029 ALPL=0.0019702 ALPLEXP=1.4003 ALPW=1.1052 ALP1L1=0.007475 ALP1LEXP=0.80983 ALP1L2=0.719 ALP1W=0.56703 ALP2L1=5.413e-07 ALP2LEXP=0.2541 ALP2L2=0 ALP2W=-10 VPO=0.06567 A1O=4.7288 A1L=0.052459 A1W=0.024056 A2O=22.013 STA2O=0.018532 A3O=1.2047 A3L=-0.10308 A3W=0.0069117 A4O=0.12894 A4L=-0.05413 A4W=-0.06197 GCOO=0 IGINVLW=0 IGOVW=0 IGOVDW=0 STIGO=2 GC2O=0.375 GC3O=0.063 CHIBO=3.1 AGIDLW=70 AGIDLDW=0 BGIDLO=13 BGIDLDO=41 STBGIDLO=-0.001067 STBGIDLDO=0 CGIDLO=0 CGIDLDO=0 CGBOVL=2.522e-16 CFRDW=0 FNTO=1 FNTEXCL=0 NFALW=1.42e+25 NFBLW=574300000 NFCLW=-3.015e-08 EFO=1 LINTNOI=-3.158e-08 ALPNOI=2.708 WEDGE=1e-08 WEDGEW=0 VFBEDGEO=-1 STVFBEDGEO=0.0005 STVFBEDGEL=0 STVFBEDGEW=0 STVFBEDGELW=0 DPHIBEDGEO=0 DPHIBEDGEL=0 DPHIBEDGELEXP=1 DPHIBEDGEW=0 DPHIBEDGELW=0 NSUBEDGEO=5e+23 NSUBEDGEL=0 NSUBEDGELEXP=1 NSUBEDGEW=0 NSUBEDGELW=0 CTEDGEO=0 CTEDGEL=0 CTEDGELEXP=1 FBETEDGE=0 LPEDGE=1e-08 BETEDGEW=0 STBETEDGEO=1 STBETEDGEL=0 STBETEDGEW=0 STBETEDGELW=0 PSCEEDGEL=0 PSCEEDGELEXP=2 PSCEEDGEW=0 PSCEBEDGEO=0 PSCEDEDGEO=0 CFEDGEL=0 CFEDGELEXP=2 CFEDGEW=0 CFDEDGEO=0 CFBEDGEO=0 FNTEDGEO=1 NFAEDGELW=8e+22 NFBEDGELW=30000000 NFCEDGELW=0 EFEDGEO=1 SAREF=1e-06 SBREF=1e-06 WLOD=0 KUO=0 KVSAT=0 TKUO=0 LKUO=0 WKUO=0 PKUO=0 LLODKUO=0 WLODKUO=0 KVTHO=0 LKVTHO=0 WKVTHO=0 PKVTHO=0 LLODVTH=0 WLODVTH=0 STETAO=0 LODETAO=1 SCREF=1e-06 WEB=0 WEC=0 KVTHOWEO=0 KVTHOWEL=0 KVTHOWEW=0 KVTHOWELW=0 KUOWEO=0 KUOWEL=0 KUOWEW=0 KUOWELW=0 TRJ=21 SWJUNEXP=0 IMAX=0.0020128 FREV=1000 CJORBOT=0.00085856 CJORSTI=2.4557e-11 CJORGAT=1.3846e-11 VBIRBOT=0.74373 VBIRSTI=1.597 VBIRGAT=0.6629 PBOT=0.27424 PSTI=0.16571 PGAT=0.1451 CJORBOTD=0.001 CJORSTID=1e-09 CJORGATD=1e-09 VBIRBOTD=1 VBIRSTID=1 VBIRGATD=1 PBOTD=0.5 PSTID=0.5 PGATD=0.5 PHIGBOT=1.1984 PHIGSTI=1.006 PHIGGAT=0.3 IDSATRBOT=5.397e-08 IDSATRSTI=4.0612e-15 IDSATRGAT=0 CSRHBOT=100 CSRHSTI=0.0001 CSRHGAT=0.0001 XJUNSTI=1.61e-08 XJUNGAT=6.134e-07 PHIGBOTD=1.16 PHIGSTID=1.16 PHIGGATD=1.16 IDSATRBOTD=1e-12 IDSATRSTID=1e-18 IDSATRGATD=1e-18 CSRHBOTD=100 CSRHSTID=0.0001 CSRHGATD=0.0001 XJUNSTID=1e-07 XJUNGATD=1e-07 CTATBOT=100 CTATSTI=0.0001 CTATGAT=0.0001 MEFFTATBOT=0.25 MEFFTATSTI=0.25 MEFFTATGAT=0.25 CTATBOTD=100 CTATSTID=0.0001 CTATGATD=0.0001 MEFFTATBOTD=0.25 MEFFTATSTID=0.25 MEFFTATGATD=0.25 CBBTBOT=1e-12 CBBTSTI=1e-21 CBBTGAT=1e-18 FBBTRBOT=1000000000 FBBTRSTI=1000000000 FBBTRGAT=1000000000 STFBBTBOT=-0.001 STFBBTSTI=-0.001 STFBBTGAT=-0.001 CBBTBOTD=1e-12 CBBTSTID=1e-18 CBBTGATD=1e-18 FBBTRBOTD=1000000000 FBBTRSTID=1000000000 FBBTRGATD=1000000000 STFBBTBOTD=-0.001 STFBBTSTID=-0.001 STFBBTGATD=-0.001 VBRBOT=10 VBRSTI=10 VBRGAT=10 PBRBOT=4 PBRSTI=4 PBRGAT=4 VBRBOTD=10 VBRSTID=10 VBRGATD=10 PBRBOTD=4 PBRSTID=4 PBRGATD=4 VJUNREF=2.5 FJUNQ=0.03 VJUNREFD=2.5 FJUNQD=0.03 RINT=3.0856e-12 RVPOLY=0 DLSIL=0 RSH=0 RSHD=0 CFRW=1.2e-16 RSHG=20 RGO=35 RBULKO=530.147287 RWELLO=530.147287 RJUNSO=596.4156978 RJUNDO=596.4156978 SWSOA=0 VGS_MAX=3 VGD_MAX=3 VGB_MAX=3 VDS_MAX=3 VDB_MAX=1.6 VSB_MAX=1.6
model hvn_w4000n_l1000n_ng1 PSP103VA TYPE=1 TR=27 DTA=0 SWGEO=1 SWIGATE=1 SWIMPACT=1 SWGIDL=0 SWJUNCAP=3 SWJUNASYM=0 SWNUD=0 SWEDGE=0 SWDELVTAC=0 SWIGN=1 QMC=1 LVARO=3.499e-08 LVARL=-0.09125 LVARW=0 LAP=6.3866e-08 WVARO=0 WVARL=0 WVARW=0 WOT=3e-08 DLQ=5.2202e-08 DWQ=3e-08 VFBO=-0.89839 VFBL=0.15096 VFBW=0.0017033 VFBLW=0.019398 STVFBO=0.0008739 STVFBL=0.00014864 STVFBW=-4.6174e-05 STVFBLW=-2.445e-06 ST2VFBO=0 TOXO=7.4256e-09 EPSROXO=3.9 NSUBO=1.8552e+23 NSUBW=-0.0050198 WSEG=1.098e-10 NPCK=3.178e+23 NPCKW=-2.7604 WSEGP=1e-08 LPCK=1e-08 LPCKW=0 FOL1=0.21033 FOL2=0.0026472 FACNEFFACO=1 FACNEFFACL=0 FACNEFFACW=0 FACNEFFACLW=0 GFACNUDO=1 GFACNUDL=0 GFACNUDLEXP=1 GFACNUDW=0 GFACNUDLW=0 VSBNUDO=0 DVSBNUDO=1 VNSUBO=0 NSLPO=0.05 DNSUBO=0.025686 DPHIBO=-0.0607576464 DPHIBL=-0.00546403785 DPHIBLEXP=2.3956 DPHIBW=0.014614 DPHIBLW=-0.017476272 DELVTACO=0 DELVTACL=0 DELVTACLEXP=1 DELVTACW=0 DELVTACLW=0 NPO=3.897e+26 NPL=-0.1215 TOXOVO=7.4256e-09 TOXOVDO=2e-09 LOV=6.3866e-08 LOVD=0 NOVO=5.5814e+24 NOVDO=5e+25 CTO=-0.061658 CTL=0.025 CTLEXP=1.6063 CTW=-0.044911 CTLW=-0.0077386 CTGO=0 CTBO=0 STCTO=1 CFL=0.0048288 CFLEXP=1.3328 CFW=0.037319 CFBO=0.26069 CFDO=0 PSCEL=0 PSCELEXP=2 PSCEW=0 PSCEBO=0 PSCEDO=0 UO=0.046687 FBET1=-0.35712 FBET1W=-0.14995 LP1=4.5615e-08 LP1W=0.4189 FBET2=-1.0245 LP2=9.42e-09 BETW1=0.6567 BETW2=-0.083639 WBET=1.0063e-10 STBETO=1.6942 STBETL=-0.0065587 STBETW=-0.060053 STBETLW=0.00036994 MUEO=0.91692524 MUEW=-0.018226 STMUEO=0.34067 THEMUO=2.5509 STTHEMUO=0.63756 CSO=2.0494 CSL=-0.97261 CSLEXP=0 CSW=0.044205 CSLW=-1.0021 STCSO=2.5545 THECSO=2 STTHECSO=0 XCORO=0.04872 XCORL=-0.27137 XCORW=-0.1948 XCORLW=0 STXCORO=1.1327 FETAO=1.0706 RSW1=321.598966 RSW2=-0.07 STRSO=-0.058157 RSBO=-0.0025425 RSGO=0.10986 THESATO=0.1 THESATL=0.446499 THESATLEXP=1.0973 THESATW=0.082797 THESATLW=-0.032897685 STTHESATO=0.48396 STTHESATL=0.50226 STTHESATW=0.049985 STTHESATLW=-0.059487 THESATBO=0.06 THESATGO=0.050814 AXO=8.7694 AXL=2.3029 ALPL=0.0019702 ALPLEXP=1.4003 ALPW=1.1052 ALP1L1=0.007475 ALP1LEXP=0.80983 ALP1L2=0.719 ALP1W=0.56703 ALP2L1=5.413e-07 ALP2LEXP=0.2541 ALP2L2=0 ALP2W=-10 VPO=0.06567 A1O=4.7288 A1L=0.052459 A1W=0.024056 A2O=22.013 STA2O=0.018532 A3O=1.2047 A3L=-0.10308 A3W=0.0069117 A4O=0.12894 A4L=-0.05413 A4W=-0.06197 GCOO=0 IGINVLW=0 IGOVW=0 IGOVDW=0 STIGO=2 GC2O=0.375 GC3O=0.063 CHIBO=3.1 AGIDLW=70 AGIDLDW=0 BGIDLO=13 BGIDLDO=41 STBGIDLO=-0.001067 STBGIDLDO=0 CGIDLO=0 CGIDLDO=0 CGBOVL=2.522e-16 CFRDW=0 FNTO=1 FNTEXCL=0 NFALW=1.42e+25 NFBLW=574300000 NFCLW=-3.015e-08 EFO=1 LINTNOI=-3.158e-08 ALPNOI=2.708 WEDGE=1e-08 WEDGEW=0 VFBEDGEO=-1 STVFBEDGEO=0.0005 STVFBEDGEL=0 STVFBEDGEW=0 STVFBEDGELW=0 DPHIBEDGEO=0 DPHIBEDGEL=0 DPHIBEDGELEXP=1 DPHIBEDGEW=0 DPHIBEDGELW=0 NSUBEDGEO=5e+23 NSUBEDGEL=0 NSUBEDGELEXP=1 NSUBEDGEW=0 NSUBEDGELW=0 CTEDGEO=0 CTEDGEL=0 CTEDGELEXP=1 FBETEDGE=0 LPEDGE=1e-08 BETEDGEW=0 STBETEDGEO=1 STBETEDGEL=0 STBETEDGEW=0 STBETEDGELW=0 PSCEEDGEL=0 PSCEEDGELEXP=2 PSCEEDGEW=0 PSCEBEDGEO=0 PSCEDEDGEO=0 CFEDGEL=0 CFEDGELEXP=2 CFEDGEW=0 CFDEDGEO=0 CFBEDGEO=0 FNTEDGEO=1 NFAEDGELW=8e+22 NFBEDGELW=30000000 NFCEDGELW=0 EFEDGEO=1 SAREF=1e-06 SBREF=1e-06 WLOD=0 KUO=0 KVSAT=0 TKUO=0 LKUO=0 WKUO=0 PKUO=0 LLODKUO=0 WLODKUO=0 KVTHO=0 LKVTHO=0 WKVTHO=0 PKVTHO=0 LLODVTH=0 WLODVTH=0 STETAO=0 LODETAO=1 SCREF=1e-06 WEB=0 WEC=0 KVTHOWEO=0 KVTHOWEL=0 KVTHOWEW=0 KVTHOWELW=0 KUOWEO=0 KUOWEL=0 KUOWEW=0 KUOWELW=0 TRJ=21 SWJUNEXP=0 IMAX=0.0020128 FREV=1000 CJORBOT=0.00085856 CJORSTI=2.4557e-11 CJORGAT=1.3846e-11 VBIRBOT=0.74373 VBIRSTI=1.597 VBIRGAT=0.6629 PBOT=0.27424 PSTI=0.16571 PGAT=0.1451 CJORBOTD=0.001 CJORSTID=1e-09 CJORGATD=1e-09 VBIRBOTD=1 VBIRSTID=1 VBIRGATD=1 PBOTD=0.5 PSTID=0.5 PGATD=0.5 PHIGBOT=1.1984 PHIGSTI=1.006 PHIGGAT=0.3 IDSATRBOT=5.397e-08 IDSATRSTI=4.0612e-15 IDSATRGAT=0 CSRHBOT=100 CSRHSTI=0.0001 CSRHGAT=0.0001 XJUNSTI=1.61e-08 XJUNGAT=6.134e-07 PHIGBOTD=1.16 PHIGSTID=1.16 PHIGGATD=1.16 IDSATRBOTD=1e-12 IDSATRSTID=1e-18 IDSATRGATD=1e-18 CSRHBOTD=100 CSRHSTID=0.0001 CSRHGATD=0.0001 XJUNSTID=1e-07 XJUNGATD=1e-07 CTATBOT=100 CTATSTI=0.0001 CTATGAT=0.0001 MEFFTATBOT=0.25 MEFFTATSTI=0.25 MEFFTATGAT=0.25 CTATBOTD=100 CTATSTID=0.0001 CTATGATD=0.0001 MEFFTATBOTD=0.25 MEFFTATSTID=0.25 MEFFTATGATD=0.25 CBBTBOT=1e-12 CBBTSTI=1e-21 CBBTGAT=1e-18 FBBTRBOT=1000000000 FBBTRSTI=1000000000 FBBTRGAT=1000000000 STFBBTBOT=-0.001 STFBBTSTI=-0.001 STFBBTGAT=-0.001 CBBTBOTD=1e-12 CBBTSTID=1e-18 CBBTGATD=1e-18 FBBTRBOTD=1000000000 FBBTRSTID=1000000000 FBBTRGATD=1000000000 STFBBTBOTD=-0.001 STFBBTSTID=-0.001 STFBBTGATD=-0.001 VBRBOT=10 VBRSTI=10 VBRGAT=10 PBRBOT=4 PBRSTI=4 PBRGAT=4 VBRBOTD=10 VBRSTID=10 VBRGATD=10 PBRBOTD=4 PBRSTID=4 PBRGATD=4 VJUNREF=2.5 FJUNQ=0.03 VJUNREFD=2.5 FJUNQD=0.03 RINT=3.0856e-12 RVPOLY=0 DLSIL=0 RSH=0 RSHD=0 CFRW=1.2e-16 RSHG=20 RGO=35 RBULKO=500 RWELLO=500 RJUNSO=1250 RJUNDO=1250 SWSOA=0 VGS_MAX=3 VGD_MAX=3 VGB_MAX=3 VDS_MAX=3 VDB_MAX=1.6 VSB_MAX=1.6
model hvn_w5683n_l450n_ng1 PSP103VA TYPE=1 TR=27 DTA=0 SWGEO=1 SWIGATE=1 SWIMPACT=1 SWGIDL=0 SWJUNCAP=3 SWJUNASYM=0 SWNUD=0 SWEDGE=0 SWDELVTAC=0 SWIGN=1 QMC=1 LVARO=3.499e-08 LVARL=-0.09125 LVARW=0 LAP=6.3866e-08 WVARO=0 WVARL=0 WVARW=0 WOT=3e-08 DLQ=5.2202e-08 DWQ=3e-08 VFBO=-0.89839 VFBL=0.15096 VFBW=0.0017033 VFBLW=0.019398 STVFBO=0.0008739 STVFBL=0.00014864 STVFBW=-4.6174e-05 STVFBLW=-2.445e-06 ST2VFBO=0 TOXO=7.4256e-09 EPSROXO=3.9 NSUBO=1.8552e+23 NSUBW=-0.0050198 WSEG=1.098e-10 NPCK=3.178e+23 NPCKW=-2.7604 WSEGP=1e-08 LPCK=1e-08 LPCKW=0 FOL1=0.21033 FOL2=0.0026472 FACNEFFACO=1 FACNEFFACL=0 FACNEFFACW=0 FACNEFFACLW=0 GFACNUDO=1 GFACNUDL=0 GFACNUDLEXP=1 GFACNUDW=0 GFACNUDLW=0 VSBNUDO=0 DVSBNUDO=1 VNSUBO=0 NSLPO=0.05 DNSUBO=0.025686 DPHIBO=-0.0607576464 DPHIBL=-0.00546403785 DPHIBLEXP=2.3956 DPHIBW=0.014614 DPHIBLW=-0.017476272 DELVTACO=0 DELVTACL=0 DELVTACLEXP=1 DELVTACW=0 DELVTACLW=0 NPO=3.897e+26 NPL=-0.1215 TOXOVO=7.4256e-09 TOXOVDO=2e-09 LOV=6.3866e-08 LOVD=0 NOVO=5.5814e+24 NOVDO=5e+25 CTO=-0.061658 CTL=0.025 CTLEXP=1.6063 CTW=-0.044911 CTLW=-0.0077386 CTGO=0 CTBO=0 STCTO=1 CFL=0.0048288 CFLEXP=1.3328 CFW=0.037319 CFBO=0.26069 CFDO=0 PSCEL=0 PSCELEXP=2 PSCEW=0 PSCEBO=0 PSCEDO=0 UO=0.046687 FBET1=-0.35712 FBET1W=-0.14995 LP1=4.5615e-08 LP1W=0.4189 FBET2=-1.0245 LP2=9.42e-09 BETW1=0.6567 BETW2=-0.083639 WBET=1.0063e-10 STBETO=1.6942 STBETL=-0.0065587 STBETW=-0.060053 STBETLW=0.00036994 MUEO=0.91692524 MUEW=-0.018226 STMUEO=0.34067 THEMUO=2.5509 STTHEMUO=0.63756 CSO=2.0494 CSL=-0.97261 CSLEXP=0 CSW=0.044205 CSLW=-1.0021 STCSO=2.5545 THECSO=2 STTHECSO=0 XCORO=0.04872 XCORL=-0.27137 XCORW=-0.1948 XCORLW=0 STXCORO=1.1327 FETAO=1.0706 RSW1=321.598966 RSW2=-0.07 STRSO=-0.058157 RSBO=-0.0025425 RSGO=0.10986 THESATO=0.1 THESATL=0.446499 THESATLEXP=1.0973 THESATW=0.082797 THESATLW=-0.032897685 STTHESATO=0.48396 STTHESATL=0.50226 STTHESATW=0.049985 STTHESATLW=-0.059487 THESATBO=0.06 THESATGO=0.050814 AXO=8.7694 AXL=2.3029 ALPL=0.0019702 ALPLEXP=1.4003 ALPW=1.1052 ALP1L1=0.007475 ALP1LEXP=0.80983 ALP1L2=0.719 ALP1W=0.56703 ALP2L1=5.413e-07 ALP2LEXP=0.2541 ALP2L2=0 ALP2W=-10 VPO=0.06567 A1O=4.7288 A1L=0.052459 A1W=0.024056 A2O=22.013 STA2O=0.018532 A3O=1.2047 A3L=-0.10308 A3W=0.0069117 A4O=0.12894 A4L=-0.05413 A4W=-0.06197 GCOO=0 IGINVLW=0 IGOVW=0 IGOVDW=0 STIGO=2 GC2O=0.375 GC3O=0.063 CHIBO=3.1 AGIDLW=70 AGIDLDW=0 BGIDLO=13 BGIDLDO=41 STBGIDLO=-0.001067 STBGIDLDO=0 CGIDLO=0 CGIDLDO=0 CGBOVL=2.522e-16 CFRDW=0 FNTO=1 FNTEXCL=0 NFALW=1.42e+25 NFBLW=574300000 NFCLW=-3.015e-08 EFO=1 LINTNOI=-3.158e-08 ALPNOI=2.708 WEDGE=1e-08 WEDGEW=0 VFBEDGEO=-1 STVFBEDGEO=0.0005 STVFBEDGEL=0 STVFBEDGEW=0 STVFBEDGELW=0 DPHIBEDGEO=0 DPHIBEDGEL=0 DPHIBEDGELEXP=1 DPHIBEDGEW=0 DPHIBEDGELW=0 NSUBEDGEO=5e+23 NSUBEDGEL=0 NSUBEDGELEXP=1 NSUBEDGEW=0 NSUBEDGELW=0 CTEDGEO=0 CTEDGEL=0 CTEDGELEXP=1 FBETEDGE=0 LPEDGE=1e-08 BETEDGEW=0 STBETEDGEO=1 STBETEDGEL=0 STBETEDGEW=0 STBETEDGELW=0 PSCEEDGEL=0 PSCEEDGELEXP=2 PSCEEDGEW=0 PSCEBEDGEO=0 PSCEDEDGEO=0 CFEDGEL=0 CFEDGELEXP=2 CFEDGEW=0 CFDEDGEO=0 CFBEDGEO=0 FNTEDGEO=1 NFAEDGELW=8e+22 NFBEDGELW=30000000 NFCEDGELW=0 EFEDGEO=1 SAREF=1e-06 SBREF=1e-06 WLOD=0 KUO=0 KVSAT=0 TKUO=0 LKUO=0 WKUO=0 PKUO=0 LLODKUO=0 WLODKUO=0 KVTHO=0 LKVTHO=0 WKVTHO=0 PKVTHO=0 LLODVTH=0 WLODVTH=0 STETAO=0 LODETAO=1 SCREF=1e-06 WEB=0 WEC=0 KVTHOWEO=0 KVTHOWEL=0 KVTHOWEW=0 KVTHOWELW=0 KUOWEO=0 KUOWEL=0 KUOWEW=0 KUOWELW=0 TRJ=21 SWJUNEXP=0 IMAX=0.0020128 FREV=1000 CJORBOT=0.00085856 CJORSTI=2.4557e-11 CJORGAT=1.3846e-11 VBIRBOT=0.74373 VBIRSTI=1.597 VBIRGAT=0.6629 PBOT=0.27424 PSTI=0.16571 PGAT=0.1451 CJORBOTD=0.001 CJORSTID=1e-09 CJORGATD=1e-09 VBIRBOTD=1 VBIRSTID=1 VBIRGATD=1 PBOTD=0.5 PSTID=0.5 PGATD=0.5 PHIGBOT=1.1984 PHIGSTI=1.006 PHIGGAT=0.3 IDSATRBOT=5.397e-08 IDSATRSTI=4.0612e-15 IDSATRGAT=0 CSRHBOT=100 CSRHSTI=0.0001 CSRHGAT=0.0001 XJUNSTI=1.61e-08 XJUNGAT=6.134e-07 PHIGBOTD=1.16 PHIGSTID=1.16 PHIGGATD=1.16 IDSATRBOTD=1e-12 IDSATRSTID=1e-18 IDSATRGATD=1e-18 CSRHBOTD=100 CSRHSTID=0.0001 CSRHGATD=0.0001 XJUNSTID=1e-07 XJUNGATD=1e-07 CTATBOT=100 CTATSTI=0.0001 CTATGAT=0.0001 MEFFTATBOT=0.25 MEFFTATSTI=0.25 MEFFTATGAT=0.25 CTATBOTD=100 CTATSTID=0.0001 CTATGATD=0.0001 MEFFTATBOTD=0.25 MEFFTATSTID=0.25 MEFFTATGATD=0.25 CBBTBOT=1e-12 CBBTSTI=1e-21 CBBTGAT=1e-18 FBBTRBOT=1000000000 FBBTRSTI=1000000000 FBBTRGAT=1000000000 STFBBTBOT=-0.001 STFBBTSTI=-0.001 STFBBTGAT=-0.001 CBBTBOTD=1e-12 CBBTSTID=1e-18 CBBTGATD=1e-18 FBBTRBOTD=1000000000 FBBTRSTID=1000000000 FBBTRGATD=1000000000 STFBBTBOTD=-0.001 STFBBTSTID=-0.001 STFBBTGATD=-0.001 VBRBOT=10 VBRSTI=10 VBRGAT=10 PBRBOT=4 PBRSTI=4 PBRGAT=4 VBRBOTD=10 VBRSTID=10 VBRGATD=10 PBRBOTD=4 PBRSTID=4 PBRGATD=4 VJUNREF=2.5 FJUNQ=0.03 VJUNREFD=2.5 FJUNQD=0.03 RINT=3.0856e-12 RVPOLY=0 DLSIL=0 RSH=0 RSHD=0 CFRW=1.2e-16 RSHG=20 RGO=35 RBULKO=351.8976 RWELLO=351.8976 RJUNSO=395.8848 RJUNDO=395.8848 SWSOA=0 VGS_MAX=3 VGD_MAX=3 VGB_MAX=3 VDS_MAX=3 VDB_MAX=1.6 VSB_MAX=1.6
model hvn_w5755n_l450n_ng1 PSP103VA TYPE=1 TR=27 DTA=0 SWGEO=1 SWIGATE=1 SWIMPACT=1 SWGIDL=0 SWJUNCAP=3 SWJUNASYM=0 SWNUD=0 SWEDGE=0 SWDELVTAC=0 SWIGN=1 QMC=1 LVARO=3.499e-08 LVARL=-0.09125 LVARW=0 LAP=6.3866e-08 WVARO=0 WVARL=0 WVARW=0 WOT=3e-08 DLQ=5.2202e-08 DWQ=3e-08 VFBO=-0.89839 VFBL=0.15096 VFBW=0.0017033 VFBLW=0.019398 STVFBO=0.0008739 STVFBL=0.00014864 STVFBW=-4.6174e-05 STVFBLW=-2.445e-06 ST2VFBO=0 TOXO=7.4256e-09 EPSROXO=3.9 NSUBO=1.8552e+23 NSUBW=-0.0050198 WSEG=1.098e-10 NPCK=3.178e+23 NPCKW=-2.7604 WSEGP=1e-08 LPCK=1e-08 LPCKW=0 FOL1=0.21033 FOL2=0.0026472 FACNEFFACO=1 FACNEFFACL=0 FACNEFFACW=0 FACNEFFACLW=0 GFACNUDO=1 GFACNUDL=0 GFACNUDLEXP=1 GFACNUDW=0 GFACNUDLW=0 VSBNUDO=0 DVSBNUDO=1 VNSUBO=0 NSLPO=0.05 DNSUBO=0.025686 DPHIBO=-0.0607576464 DPHIBL=-0.00546403785 DPHIBLEXP=2.3956 DPHIBW=0.014614 DPHIBLW=-0.017476272 DELVTACO=0 DELVTACL=0 DELVTACLEXP=1 DELVTACW=0 DELVTACLW=0 NPO=3.897e+26 NPL=-0.1215 TOXOVO=7.4256e-09 TOXOVDO=2e-09 LOV=6.3866e-08 LOVD=0 NOVO=5.5814e+24 NOVDO=5e+25 CTO=-0.061658 CTL=0.025 CTLEXP=1.6063 CTW=-0.044911 CTLW=-0.0077386 CTGO=0 CTBO=0 STCTO=1 CFL=0.0048288 CFLEXP=1.3328 CFW=0.037319 CFBO=0.26069 CFDO=0 PSCEL=0 PSCELEXP=2 PSCEW=0 PSCEBO=0 PSCEDO=0 UO=0.046687 FBET1=-0.35712 FBET1W=-0.14995 LP1=4.5615e-08 LP1W=0.4189 FBET2=-1.0245 LP2=9.42e-09 BETW1=0.6567 BETW2=-0.083639 WBET=1.0063e-10 STBETO=1.6942 STBETL=-0.0065587 STBETW=-0.060053 STBETLW=0.00036994 MUEO=0.91692524 MUEW=-0.018226 STMUEO=0.34067 THEMUO=2.5509 STTHEMUO=0.63756 CSO=2.0494 CSL=-0.97261 CSLEXP=0 CSW=0.044205 CSLW=-1.0021 STCSO=2.5545 THECSO=2 STTHECSO=0 XCORO=0.04872 XCORL=-0.27137 XCORW=-0.1948 XCORLW=0 STXCORO=1.1327 FETAO=1.0706 RSW1=321.598966 RSW2=-0.07 STRSO=-0.058157 RSBO=-0.0025425 RSGO=0.10986 THESATO=0.1 THESATL=0.446499 THESATLEXP=1.0973 THESATW=0.082797 THESATLW=-0.032897685 STTHESATO=0.48396 STTHESATL=0.50226 STTHESATW=0.049985 STTHESATLW=-0.059487 THESATBO=0.06 THESATGO=0.050814 AXO=8.7694 AXL=2.3029 ALPL=0.0019702 ALPLEXP=1.4003 ALPW=1.1052 ALP1L1=0.007475 ALP1LEXP=0.80983 ALP1L2=0.719 ALP1W=0.56703 ALP2L1=5.413e-07 ALP2LEXP=0.2541 ALP2L2=0 ALP2W=-10 VPO=0.06567 A1O=4.7288 A1L=0.052459 A1W=0.024056 A2O=22.013 STA2O=0.018532 A3O=1.2047 A3L=-0.10308 A3W=0.0069117 A4O=0.12894 A4L=-0.05413 A4W=-0.06197 GCOO=0 IGINVLW=0 IGOVW=0 IGOVDW=0 STIGO=2 GC2O=0.375 GC3O=0.063 CHIBO=3.1 AGIDLW=70 AGIDLDW=0 BGIDLO=13 BGIDLDO=41 STBGIDLO=-0.001067 STBGIDLDO=0 CGIDLO=0 CGIDLDO=0 CGBOVL=2.522e-16 CFRDW=0 FNTO=1 FNTEXCL=0 NFALW=1.42e+25 NFBLW=574300000 NFCLW=-3.015e-08 EFO=1 LINTNOI=-3.158e-08 ALPNOI=2.708 WEDGE=1e-08 WEDGEW=0 VFBEDGEO=-1 STVFBEDGEO=0.0005 STVFBEDGEL=0 STVFBEDGEW=0 STVFBEDGELW=0 DPHIBEDGEO=0 DPHIBEDGEL=0 DPHIBEDGELEXP=1 DPHIBEDGEW=0 DPHIBEDGELW=0 NSUBEDGEO=5e+23 NSUBEDGEL=0 NSUBEDGELEXP=1 NSUBEDGEW=0 NSUBEDGELW=0 CTEDGEO=0 CTEDGEL=0 CTEDGELEXP=1 FBETEDGE=0 LPEDGE=1e-08 BETEDGEW=0 STBETEDGEO=1 STBETEDGEL=0 STBETEDGEW=0 STBETEDGELW=0 PSCEEDGEL=0 PSCEEDGELEXP=2 PSCEEDGEW=0 PSCEBEDGEO=0 PSCEDEDGEO=0 CFEDGEL=0 CFEDGELEXP=2 CFEDGEW=0 CFDEDGEO=0 CFBEDGEO=0 FNTEDGEO=1 NFAEDGELW=8e+22 NFBEDGELW=30000000 NFCEDGELW=0 EFEDGEO=1 SAREF=1e-06 SBREF=1e-06 WLOD=0 KUO=0 KVSAT=0 TKUO=0 LKUO=0 WKUO=0 PKUO=0 LLODKUO=0 WLODKUO=0 KVTHO=0 LKVTHO=0 WKVTHO=0 PKVTHO=0 LLODVTH=0 WLODVTH=0 STETAO=0 LODETAO=1 SCREF=1e-06 WEB=0 WEC=0 KVTHOWEO=0 KVTHOWEL=0 KVTHOWEW=0 KVTHOWELW=0 KUOWEO=0 KUOWEL=0 KUOWEW=0 KUOWELW=0 TRJ=21 SWJUNEXP=0 IMAX=0.0020128 FREV=1000 CJORBOT=0.00085856 CJORSTI=2.4557e-11 CJORGAT=1.3846e-11 VBIRBOT=0.74373 VBIRSTI=1.597 VBIRGAT=0.6629 PBOT=0.27424 PSTI=0.16571 PGAT=0.1451 CJORBOTD=0.001 CJORSTID=1e-09 CJORGATD=1e-09 VBIRBOTD=1 VBIRSTID=1 VBIRGATD=1 PBOTD=0.5 PSTID=0.5 PGATD=0.5 PHIGBOT=1.1984 PHIGSTI=1.006 PHIGGAT=0.3 IDSATRBOT=5.397e-08 IDSATRSTI=4.0612e-15 IDSATRGAT=0 CSRHBOT=100 CSRHSTI=0.0001 CSRHGAT=0.0001 XJUNSTI=1.61e-08 XJUNGAT=6.134e-07 PHIGBOTD=1.16 PHIGSTID=1.16 PHIGGATD=1.16 IDSATRBOTD=1e-12 IDSATRSTID=1e-18 IDSATRGATD=1e-18 CSRHBOTD=100 CSRHSTID=0.0001 CSRHGATD=0.0001 XJUNSTID=1e-07 XJUNGATD=1e-07 CTATBOT=100 CTATSTI=0.0001 CTATGAT=0.0001 MEFFTATBOT=0.25 MEFFTATSTI=0.25 MEFFTATGAT=0.25 CTATBOTD=100 CTATSTID=0.0001 CTATGATD=0.0001 MEFFTATBOTD=0.25 MEFFTATSTID=0.25 MEFFTATGATD=0.25 CBBTBOT=1e-12 CBBTSTI=1e-21 CBBTGAT=1e-18 FBBTRBOT=1000000000 FBBTRSTI=1000000000 FBBTRGAT=1000000000 STFBBTBOT=-0.001 STFBBTSTI=-0.001 STFBBTGAT=-0.001 CBBTBOTD=1e-12 CBBTSTID=1e-18 CBBTGATD=1e-18 FBBTRBOTD=1000000000 FBBTRSTID=1000000000 FBBTRGATD=1000000000 STFBBTBOTD=-0.001 STFBBTSTID=-0.001 STFBBTGATD=-0.001 VBRBOT=10 VBRSTI=10 VBRGAT=10 PBRBOT=4 PBRSTI=4 PBRGAT=4 VBRBOTD=10 VBRSTID=10 VBRGATD=10 PBRBOTD=4 PBRSTID=4 PBRGATD=4 VJUNREF=2.5 FJUNQ=0.03 VJUNREFD=2.5 FJUNQD=0.03 RINT=3.0856e-12 RVPOLY=0 DLSIL=0 RSH=0 RSHD=0 CFRW=1.2e-16 RSHG=20 RGO=35 RBULKO=347.5531852 RWELLO=347.5531852 RJUNSO=390.9973333 RJUNDO=390.9973333 SWSOA=0 VGS_MAX=3 VGD_MAX=3 VGB_MAX=3 VDS_MAX=3 VDB_MAX=1.6 VSB_MAX=1.6
model hvp_w10000n_l400n_ng1 PSP103VA TYPE=-1 TR=27 DTA=0 SWGEO=1 SWIGATE=1 SWIMPACT=1 SWGIDL=1 SWJUNCAP=3 SWJUNASYM=0 SWNUD=0 SWEDGE=0 SWDELVTAC=0 SWIGN=1 QMC=1 LVARO=-1.735e-09 LVARL=0 LVARW=0 LAP=3.471e-08 WVARO=0 WVARL=0 WVARW=0 WOT=0 DLQ=3.537e-08 DWQ=3e-08 VFBO=-1.0717 VFBL=-0.03 VFBW=0 VFBLW=0 STVFBO=0.00057379 STVFBL=8.6794e-05 STVFBW=4.9309e-05 STVFBLW=-3.6436e-05 ST2VFBO=0 TOXO=6.945e-09 EPSROXO=3.9 NSUBO=4.2268e+23 NSUBW=0.01112 WSEG=5.362e-08 NPCK=8.0711e+23 NPCKW=-0.011403 WSEGP=1e-06 LPCK=8.3733e-09 LPCKW=0.077499 FOL1=0.065253 FOL2=0.010199 FACNEFFACO=1 FACNEFFACL=0 FACNEFFACW=0 FACNEFFACLW=0 GFACNUDO=1 GFACNUDL=0 GFACNUDLEXP=1 GFACNUDW=0 GFACNUDLW=0 VSBNUDO=0 DVSBNUDO=1 VNSUBO=0 NSLPO=0.05 DNSUBO=0.03585 DPHIBO=-0.077884807 DPHIBL=0.00526388544 DPHIBLEXP=2.1893 DPHIBW=-0.011141504 DPHIBLW=-9.3915789e-05 DELVTACO=0 DELVTACL=0 DELVTACLEXP=1 DELVTACW=0 DELVTACLW=0 NPO=1.092e+26 NPL=0.2188 TOXOVO=6.945e-09 TOXOVDO=2e-09 LOV=3.471e-08 LOVD=0 NOVO=1.99e+26 NOVDO=5e+25 CTO=-0.006328 CTL=0 CTLEXP=1 CTW=0.3006 CTLW=-0.01196 CTGO=0 CTBO=0 STCTO=1 CFL=0.00045884 CFLEXP=2.2055 CFW=0.45909 CFBO=1 CFDO=0 PSCEL=0 PSCELEXP=2 PSCEW=0 PSCEBO=0 PSCEDO=0 UO=0.018428 FBET1=0.15952 FBET1W=-2.1872 LP1=9.9822e-08 LP1W=-1.0871 FBET2=-2.7066 LP2=5.8401e-08 BETW1=-0.097534 BETW2=0.022314 WBET=7.9844e-10 STBETO=1.6489 STBETL=0.029528 STBETW=0.037078 STBETLW=0.046991 MUEO=1.7444601 MUEW=-0.06367 STMUEO=1.0816 THEMUO=1.0324 STTHEMUO=0.26337 CSO=0.18648 CSL=0.21903 CSLEXP=2.0917 CSW=0.0072837 CSLW=0.02 STCSO=2 THECSO=2 STTHECSO=0 XCORO=0.001363 XCORL=8 XCORW=0.0060537 XCORLW=0.058951 STXCORO=-6.939e-18 FETAO=1.2853 RSW1=1970 RSW2=-0.057547 STRSO=-0.24812 RSBO=0.074639 RSGO=0.23490984 THESATO=8.4917e-05 THESATL=0.0067396 THESATLEXP=2.395 THESATW=1.1549 THESATLW=-0.01 STTHESATO=3.0405 STTHESATL=-0.16001 STTHESATW=-0.96988 STTHESATLW=0.36213 THESATBO=0.1 THESATGO=0.6304 AXO=16.822 AXL=3.0092 ALPL=0.0058454 ALPLEXP=0.47562 ALPW=-0.065973 ALP1L1=4.4409e-16 ALP1LEXP=1.347 ALP1L2=1 ALP1W=2 ALP2L1=3.6779e-06 ALP2LEXP=0.2531 ALP2L2=2.2204e-15 ALP2W=0.9582 VPO=1.8436e-06 A1O=47.788 A1L=0.029145 A1W=0.01435 A2O=38.581 STA2O=-0.0049931 A3O=1.1753 A3L=-0.069795 A3W=0.0032538 A4O=0.12593 A4L=-0.07 A4W=-0.04811 GCOO=0 IGINVLW=0 IGOVW=0 IGOVDW=0 STIGO=2 GC2O=0.375 GC3O=0.063 CHIBO=3.1 AGIDLW=6e-10 AGIDLDW=0 BGIDLO=5.5970304 BGIDLDO=41 STBGIDLO=-0.0049461 STBGIDLDO=0 CGIDLO=0.23693 CGIDLDO=0 CGBOVL=-4.669e-16 CFRDW=0 FNTO=1 FNTEXCL=0 NFALW=1.3e+25 NFBLW=5289000000 NFCLW=2e-07 EFO=1.152 LINTNOI=2.5e-08 ALPNOI=2 WEDGE=1e-08 WEDGEW=0 VFBEDGEO=-1 STVFBEDGEO=0.0005 STVFBEDGEL=0 STVFBEDGEW=0 STVFBEDGELW=0 DPHIBEDGEO=0 DPHIBEDGEL=0 DPHIBEDGELEXP=1 DPHIBEDGEW=0 DPHIBEDGELW=0 NSUBEDGEO=5e+23 NSUBEDGEL=0 NSUBEDGELEXP=1 NSUBEDGEW=0 NSUBEDGELW=0 CTEDGEO=0 CTEDGEL=0 CTEDGELEXP=1 FBETEDGE=0 LPEDGE=1e-08 BETEDGEW=0 STBETEDGEO=1 STBETEDGEL=0 STBETEDGEW=0 STBETEDGELW=0 PSCEEDGEL=0 PSCEEDGELEXP=2 PSCEEDGEW=0 PSCEBEDGEO=0 PSCEDEDGEO=0 CFEDGEL=0 CFEDGELEXP=2 CFEDGEW=0 CFDEDGEO=0 CFBEDGEO=0 FNTEDGEO=1 NFAEDGELW=8e+22 NFBEDGELW=30000000 NFCEDGELW=0 EFEDGEO=1 SAREF=1e-06 SBREF=1e-06 WLOD=0 KUO=0 KVSAT=0 TKUO=0 LKUO=0 WKUO=0 PKUO=0 LLODKUO=0 WLODKUO=0 KVTHO=0 LKVTHO=0 WKVTHO=0 PKVTHO=0 LLODVTH=0 WLODVTH=0 STETAO=0 LODETAO=1 SCREF=1e-06 WEB=0 WEC=0 KVTHOWEO=0 KVTHOWEL=0 KVTHOWEW=0 KVTHOWELW=0 KUOWEO=0 KUOWEL=0 KUOWEW=0 KUOWELW=0 TRJ=21 SWJUNEXP=0 IMAX=0.0024527 FREV=1000 CJORBOT=0.0008095 CJORSTI=4.2583e-11 CJORGAT=3.1e-11 VBIRBOT=0.72606 VBIRSTI=0.69819 VBIRGAT=1.199 PBOT=0.33078 PSTI=0.22409 PGAT=0.4474 CJORBOTD=0.001 CJORSTID=1e-09 CJORGATD=1e-09 VBIRBOTD=1 VBIRSTID=1 VBIRGATD=1 PBOTD=0.5 PSTID=0.5 PGATD=0.5 PHIGBOT=1.0641 PHIGSTI=1.3946 PHIGGAT=1.83 IDSATRBOT=3.0606e-08 IDSATRSTI=3.6127e-15 IDSATRGAT=0 CSRHBOT=100 CSRHSTI=0.0001 CSRHGAT=0.0001 XJUNSTI=4.93e-08 XJUNGAT=7.062e-07 PHIGBOTD=1.16 PHIGSTID=1.16 PHIGGATD=1.16 IDSATRBOTD=1e-12 IDSATRSTID=1e-18 IDSATRGATD=1e-18 CSRHBOTD=100 CSRHSTID=0.0001 CSRHGATD=0.0001 XJUNSTID=1e-07 XJUNGATD=1e-07 CTATBOT=100 CTATSTI=0.0001 CTATGAT=0.0001 MEFFTATBOT=0.25 MEFFTATSTI=0.25 MEFFTATGAT=0.25 CTATBOTD=100 CTATSTID=0.0001 CTATGATD=0.0001 MEFFTATBOTD=0.25 MEFFTATSTID=0.25 MEFFTATGATD=0.25 CBBTBOT=1e-12 CBBTSTI=1e-21 CBBTGAT=1e-18 FBBTRBOT=1000000000 FBBTRSTI=1000000000 FBBTRGAT=1000000000 STFBBTBOT=-0.001 STFBBTSTI=-0.001 STFBBTGAT=-0.001 CBBTBOTD=1e-12 CBBTSTID=1e-18 CBBTGATD=1e-18 FBBTRBOTD=1000000000 FBBTRSTID=1000000000 FBBTRGATD=1000000000 STFBBTBOTD=-0.001 STFBBTSTID=-0.001 STFBBTGATD=-0.001 VBRBOT=10 VBRSTI=10 VBRGAT=10 PBRBOT=4 PBRSTI=4 PBRGAT=4 VBRBOTD=10 VBRSTID=10 VBRGATD=10 PBRBOTD=4 PBRSTID=4 PBRGATD=4 VJUNREF=2.5 FJUNQ=0.03 VJUNREFD=2.5 FJUNQD=0.03 RINT=0 RVPOLY=0 DLSIL=0 RSH=0 RSHD=0 CFRW=0 RSHG=40 RGO=15 RBULKO=200 RWELLO=100 RJUNSO=200 RJUNDO=200 SWSOA=0 VGS_MAX=3 VGD_MAX=3 VGB_MAX=3 VDS_MAX=3 VDB_MAX=1.6 VSB_MAX=1.6
model hvp_w11367n_l400n_ng2 PSP103VA TYPE=-1 TR=27 DTA=0 SWGEO=1 SWIGATE=1 SWIMPACT=1 SWGIDL=1 SWJUNCAP=3 SWJUNASYM=0 SWNUD=0 SWEDGE=0 SWDELVTAC=0 SWIGN=1 QMC=1 LVARO=-1.735e-09 LVARL=0 LVARW=0 LAP=3.471e-08 WVARO=0 WVARL=0 WVARW=0 WOT=0 DLQ=3.537e-08 DWQ=3e-08 VFBO=-1.0717 VFBL=-0.03 VFBW=0 VFBLW=0 STVFBO=0.00057379 STVFBL=8.6794e-05 STVFBW=4.9309e-05 STVFBLW=-3.6436e-05 ST2VFBO=0 TOXO=6.945e-09 EPSROXO=3.9 NSUBO=4.2268e+23 NSUBW=0.01112 WSEG=5.362e-08 NPCK=8.0711e+23 NPCKW=-0.011403 WSEGP=1e-06 LPCK=8.3733e-09 LPCKW=0.077499 FOL1=0.065253 FOL2=0.010199 FACNEFFACO=1 FACNEFFACL=0 FACNEFFACW=0 FACNEFFACLW=0 GFACNUDO=1 GFACNUDL=0 GFACNUDLEXP=1 GFACNUDW=0 GFACNUDLW=0 VSBNUDO=0 DVSBNUDO=1 VNSUBO=0 NSLPO=0.05 DNSUBO=0.03585 DPHIBO=-0.077884807 DPHIBL=0.00526388544 DPHIBLEXP=2.1893 DPHIBW=-0.011141504 DPHIBLW=-9.3915789e-05 DELVTACO=0 DELVTACL=0 DELVTACLEXP=1 DELVTACW=0 DELVTACLW=0 NPO=1.092e+26 NPL=0.2188 TOXOVO=6.945e-09 TOXOVDO=2e-09 LOV=3.471e-08 LOVD=0 NOVO=1.99e+26 NOVDO=5e+25 CTO=-0.006328 CTL=0 CTLEXP=1 CTW=0.3006 CTLW=-0.01196 CTGO=0 CTBO=0 STCTO=1 CFL=0.00045884 CFLEXP=2.2055 CFW=0.45909 CFBO=1 CFDO=0 PSCEL=0 PSCELEXP=2 PSCEW=0 PSCEBO=0 PSCEDO=0 UO=0.018428 FBET1=0.15952 FBET1W=-2.1872 LP1=9.9822e-08 LP1W=-1.0871 FBET2=-2.7066 LP2=5.8401e-08 BETW1=-0.097534 BETW2=0.022314 WBET=7.9844e-10 STBETO=1.6489 STBETL=0.029528 STBETW=0.037078 STBETLW=0.046991 MUEO=1.7444601 MUEW=-0.06367 STMUEO=1.0816 THEMUO=1.0324 STTHEMUO=0.26337 CSO=0.18648 CSL=0.21903 CSLEXP=2.0917 CSW=0.0072837 CSLW=0.02 STCSO=2 THECSO=2 STTHECSO=0 XCORO=0.001363 XCORL=8 XCORW=0.0060537 XCORLW=0.058951 STXCORO=-6.939e-18 FETAO=1.2853 RSW1=1970 RSW2=-0.057547 STRSO=-0.24812 RSBO=0.074639 RSGO=0.23490984 THESATO=8.4917e-05 THESATL=0.0067396 THESATLEXP=2.395 THESATW=1.1549 THESATLW=-0.01 STTHESATO=3.0405 STTHESATL=-0.16001 STTHESATW=-0.96988 STTHESATLW=0.36213 THESATBO=0.1 THESATGO=0.6304 AXO=16.822 AXL=3.0092 ALPL=0.0058454 ALPLEXP=0.47562 ALPW=-0.065973 ALP1L1=4.4409e-16 ALP1LEXP=1.347 ALP1L2=1 ALP1W=2 ALP2L1=3.6779e-06 ALP2LEXP=0.2531 ALP2L2=2.2204e-15 ALP2W=0.9582 VPO=1.8436e-06 A1O=47.788 A1L=0.029145 A1W=0.01435 A2O=38.581 STA2O=-0.0049931 A3O=1.1753 A3L=-0.069795 A3W=0.0032538 A4O=0.12593 A4L=-0.07 A4W=-0.04811 GCOO=0 IGINVLW=0 IGOVW=0 IGOVDW=0 STIGO=2 GC2O=0.375 GC3O=0.063 CHIBO=3.1 AGIDLW=6e-10 AGIDLDW=0 BGIDLO=5.5970304 BGIDLDO=41 STBGIDLO=-0.0049461 STBGIDLDO=0 CGIDLO=0.23693 CGIDLDO=0 CGBOVL=-4.669e-16 CFRDW=0 FNTO=1 FNTEXCL=0 NFALW=1.3e+25 NFBLW=5289000000 NFCLW=2e-07 EFO=1.152 LINTNOI=2.5e-08 ALPNOI=2 WEDGE=1e-08 WEDGEW=0 VFBEDGEO=-1 STVFBEDGEO=0.0005 STVFBEDGEL=0 STVFBEDGEW=0 STVFBEDGELW=0 DPHIBEDGEO=0 DPHIBEDGEL=0 DPHIBEDGELEXP=1 DPHIBEDGEW=0 DPHIBEDGELW=0 NSUBEDGEO=5e+23 NSUBEDGEL=0 NSUBEDGELEXP=1 NSUBEDGEW=0 NSUBEDGELW=0 CTEDGEO=0 CTEDGEL=0 CTEDGELEXP=1 FBETEDGE=0 LPEDGE=1e-08 BETEDGEW=0 STBETEDGEO=1 STBETEDGEL=0 STBETEDGEW=0 STBETEDGELW=0 PSCEEDGEL=0 PSCEEDGELEXP=2 PSCEEDGEW=0 PSCEBEDGEO=0 PSCEDEDGEO=0 CFEDGEL=0 CFEDGELEXP=2 CFEDGEW=0 CFDEDGEO=0 CFBEDGEO=0 FNTEDGEO=1 NFAEDGELW=8e+22 NFBEDGELW=30000000 NFCEDGELW=0 EFEDGEO=1 SAREF=1e-06 SBREF=1e-06 WLOD=0 KUO=0 KVSAT=0 TKUO=0 LKUO=0 WKUO=0 PKUO=0 LLODKUO=0 WLODKUO=0 KVTHO=0 LKVTHO=0 WKVTHO=0 PKVTHO=0 LLODVTH=0 WLODVTH=0 STETAO=0 LODETAO=1 SCREF=1e-06 WEB=0 WEC=0 KVTHOWEO=0 KVTHOWEL=0 KVTHOWEW=0 KVTHOWELW=0 KUOWEO=0 KUOWEL=0 KUOWEW=0 KUOWELW=0 TRJ=21 SWJUNEXP=0 IMAX=0.0024527 FREV=1000 CJORBOT=0.0008095 CJORSTI=4.2583e-11 CJORGAT=3.1e-11 VBIRBOT=0.72606 VBIRSTI=0.69819 VBIRGAT=1.199 PBOT=0.33078 PSTI=0.22409 PGAT=0.4474 CJORBOTD=0.001 CJORSTID=1e-09 CJORGATD=1e-09 VBIRBOTD=1 VBIRSTID=1 VBIRGATD=1 PBOTD=0.5 PSTID=0.5 PGATD=0.5 PHIGBOT=1.0641 PHIGSTI=1.3946 PHIGGAT=1.83 IDSATRBOT=3.0606e-08 IDSATRSTI=3.6127e-15 IDSATRGAT=0 CSRHBOT=100 CSRHSTI=0.0001 CSRHGAT=0.0001 XJUNSTI=4.93e-08 XJUNGAT=7.062e-07 PHIGBOTD=1.16 PHIGSTID=1.16 PHIGGATD=1.16 IDSATRBOTD=1e-12 IDSATRSTID=1e-18 IDSATRGATD=1e-18 CSRHBOTD=100 CSRHSTID=0.0001 CSRHGATD=0.0001 XJUNSTID=1e-07 XJUNGATD=1e-07 CTATBOT=100 CTATSTI=0.0001 CTATGAT=0.0001 MEFFTATBOT=0.25 MEFFTATSTI=0.25 MEFFTATGAT=0.25 CTATBOTD=100 CTATSTID=0.0001 CTATGATD=0.0001 MEFFTATBOTD=0.25 MEFFTATSTID=0.25 MEFFTATGATD=0.25 CBBTBOT=1e-12 CBBTSTI=1e-21 CBBTGAT=1e-18 FBBTRBOT=1000000000 FBBTRSTI=1000000000 FBBTRGAT=1000000000 STFBBTBOT=-0.001 STFBBTSTI=-0.001 STFBBTGAT=-0.001 CBBTBOTD=1e-12 CBBTSTID=1e-18 CBBTGATD=1e-18 FBBTRBOTD=1000000000 FBBTRSTID=1000000000 FBBTRGATD=1000000000 STFBBTBOTD=-0.001 STFBBTSTID=-0.001 STFBBTGATD=-0.001 VBRBOT=10 VBRSTI=10 VBRGAT=10 PBRBOT=4 PBRSTI=4 PBRGAT=4 VBRBOTD=10 VBRSTID=10 VBRGATD=10 PBRBOTD=4 PBRSTID=4 PBRGATD=4 VJUNREF=2.5 FJUNQ=0.03 VJUNREFD=2.5 FJUNQD=0.03 RINT=0 RVPOLY=0 DLSIL=0 RSH=0 RSHD=0 CFRW=0 RSHG=40 RGO=15 RBULKO=351.8976 RWELLO=175.9488 RJUNSO=175.9488 RJUNDO=175.9488 SWSOA=0 VGS_MAX=3 VGD_MAX=3 VGB_MAX=3 VDS_MAX=3 VDB_MAX=1.6 VSB_MAX=1.6
model hvp_w11509n_l400n_ng2 PSP103VA TYPE=-1 TR=27 DTA=0 SWGEO=1 SWIGATE=1 SWIMPACT=1 SWGIDL=1 SWJUNCAP=3 SWJUNASYM=0 SWNUD=0 SWEDGE=0 SWDELVTAC=0 SWIGN=1 QMC=1 LVARO=-1.735e-09 LVARL=0 LVARW=0 LAP=3.471e-08 WVARO=0 WVARL=0 WVARW=0 WOT=0 DLQ=3.537e-08 DWQ=3e-08 VFBO=-1.0717 VFBL=-0.03 VFBW=0 VFBLW=0 STVFBO=0.00057379 STVFBL=8.6794e-05 STVFBW=4.9309e-05 STVFBLW=-3.6436e-05 ST2VFBO=0 TOXO=6.945e-09 EPSROXO=3.9 NSUBO=4.2268e+23 NSUBW=0.01112 WSEG=5.362e-08 NPCK=8.0711e+23 NPCKW=-0.011403 WSEGP=1e-06 LPCK=8.3733e-09 LPCKW=0.077499 FOL1=0.065253 FOL2=0.010199 FACNEFFACO=1 FACNEFFACL=0 FACNEFFACW=0 FACNEFFACLW=0 GFACNUDO=1 GFACNUDL=0 GFACNUDLEXP=1 GFACNUDW=0 GFACNUDLW=0 VSBNUDO=0 DVSBNUDO=1 VNSUBO=0 NSLPO=0.05 DNSUBO=0.03585 DPHIBO=-0.077884807 DPHIBL=0.00526388544 DPHIBLEXP=2.1893 DPHIBW=-0.011141504 DPHIBLW=-9.3915789e-05 DELVTACO=0 DELVTACL=0 DELVTACLEXP=1 DELVTACW=0 DELVTACLW=0 NPO=1.092e+26 NPL=0.2188 TOXOVO=6.945e-09 TOXOVDO=2e-09 LOV=3.471e-08 LOVD=0 NOVO=1.99e+26 NOVDO=5e+25 CTO=-0.006328 CTL=0 CTLEXP=1 CTW=0.3006 CTLW=-0.01196 CTGO=0 CTBO=0 STCTO=1 CFL=0.00045884 CFLEXP=2.2055 CFW=0.45909 CFBO=1 CFDO=0 PSCEL=0 PSCELEXP=2 PSCEW=0 PSCEBO=0 PSCEDO=0 UO=0.018428 FBET1=0.15952 FBET1W=-2.1872 LP1=9.9822e-08 LP1W=-1.0871 FBET2=-2.7066 LP2=5.8401e-08 BETW1=-0.097534 BETW2=0.022314 WBET=7.9844e-10 STBETO=1.6489 STBETL=0.029528 STBETW=0.037078 STBETLW=0.046991 MUEO=1.7444601 MUEW=-0.06367 STMUEO=1.0816 THEMUO=1.0324 STTHEMUO=0.26337 CSO=0.18648 CSL=0.21903 CSLEXP=2.0917 CSW=0.0072837 CSLW=0.02 STCSO=2 THECSO=2 STTHECSO=0 XCORO=0.001363 XCORL=8 XCORW=0.0060537 XCORLW=0.058951 STXCORO=-6.939e-18 FETAO=1.2853 RSW1=1970 RSW2=-0.057547 STRSO=-0.24812 RSBO=0.074639 RSGO=0.23490984 THESATO=8.4917e-05 THESATL=0.0067396 THESATLEXP=2.395 THESATW=1.1549 THESATLW=-0.01 STTHESATO=3.0405 STTHESATL=-0.16001 STTHESATW=-0.96988 STTHESATLW=0.36213 THESATBO=0.1 THESATGO=0.6304 AXO=16.822 AXL=3.0092 ALPL=0.0058454 ALPLEXP=0.47562 ALPW=-0.065973 ALP1L1=4.4409e-16 ALP1LEXP=1.347 ALP1L2=1 ALP1W=2 ALP2L1=3.6779e-06 ALP2LEXP=0.2531 ALP2L2=2.2204e-15 ALP2W=0.9582 VPO=1.8436e-06 A1O=47.788 A1L=0.029145 A1W=0.01435 A2O=38.581 STA2O=-0.0049931 A3O=1.1753 A3L=-0.069795 A3W=0.0032538 A4O=0.12593 A4L=-0.07 A4W=-0.04811 GCOO=0 IGINVLW=0 IGOVW=0 IGOVDW=0 STIGO=2 GC2O=0.375 GC3O=0.063 CHIBO=3.1 AGIDLW=6e-10 AGIDLDW=0 BGIDLO=5.5970304 BGIDLDO=41 STBGIDLO=-0.0049461 STBGIDLDO=0 CGIDLO=0.23693 CGIDLDO=0 CGBOVL=-4.669e-16 CFRDW=0 FNTO=1 FNTEXCL=0 NFALW=1.3e+25 NFBLW=5289000000 NFCLW=2e-07 EFO=1.152 LINTNOI=2.5e-08 ALPNOI=2 WEDGE=1e-08 WEDGEW=0 VFBEDGEO=-1 STVFBEDGEO=0.0005 STVFBEDGEL=0 STVFBEDGEW=0 STVFBEDGELW=0 DPHIBEDGEO=0 DPHIBEDGEL=0 DPHIBEDGELEXP=1 DPHIBEDGEW=0 DPHIBEDGELW=0 NSUBEDGEO=5e+23 NSUBEDGEL=0 NSUBEDGELEXP=1 NSUBEDGEW=0 NSUBEDGELW=0 CTEDGEO=0 CTEDGEL=0 CTEDGELEXP=1 FBETEDGE=0 LPEDGE=1e-08 BETEDGEW=0 STBETEDGEO=1 STBETEDGEL=0 STBETEDGEW=0 STBETEDGELW=0 PSCEEDGEL=0 PSCEEDGELEXP=2 PSCEEDGEW=0 PSCEBEDGEO=0 PSCEDEDGEO=0 CFEDGEL=0 CFEDGELEXP=2 CFEDGEW=0 CFDEDGEO=0 CFBEDGEO=0 FNTEDGEO=1 NFAEDGELW=8e+22 NFBEDGELW=30000000 NFCEDGELW=0 EFEDGEO=1 SAREF=1e-06 SBREF=1e-06 WLOD=0 KUO=0 KVSAT=0 TKUO=0 LKUO=0 WKUO=0 PKUO=0 LLODKUO=0 WLODKUO=0 KVTHO=0 LKVTHO=0 WKVTHO=0 PKVTHO=0 LLODVTH=0 WLODVTH=0 STETAO=0 LODETAO=1 SCREF=1e-06 WEB=0 WEC=0 KVTHOWEO=0 KVTHOWEL=0 KVTHOWEW=0 KVTHOWELW=0 KUOWEO=0 KUOWEL=0 KUOWEW=0 KUOWELW=0 TRJ=21 SWJUNEXP=0 IMAX=0.0024527 FREV=1000 CJORBOT=0.0008095 CJORSTI=4.2583e-11 CJORGAT=3.1e-11 VBIRBOT=0.72606 VBIRSTI=0.69819 VBIRGAT=1.199 PBOT=0.33078 PSTI=0.22409 PGAT=0.4474 CJORBOTD=0.001 CJORSTID=1e-09 CJORGATD=1e-09 VBIRBOTD=1 VBIRSTID=1 VBIRGATD=1 PBOTD=0.5 PSTID=0.5 PGATD=0.5 PHIGBOT=1.0641 PHIGSTI=1.3946 PHIGGAT=1.83 IDSATRBOT=3.0606e-08 IDSATRSTI=3.6127e-15 IDSATRGAT=0 CSRHBOT=100 CSRHSTI=0.0001 CSRHGAT=0.0001 XJUNSTI=4.93e-08 XJUNGAT=7.062e-07 PHIGBOTD=1.16 PHIGSTID=1.16 PHIGGATD=1.16 IDSATRBOTD=1e-12 IDSATRSTID=1e-18 IDSATRGATD=1e-18 CSRHBOTD=100 CSRHSTID=0.0001 CSRHGATD=0.0001 XJUNSTID=1e-07 XJUNGATD=1e-07 CTATBOT=100 CTATSTI=0.0001 CTATGAT=0.0001 MEFFTATBOT=0.25 MEFFTATSTI=0.25 MEFFTATGAT=0.25 CTATBOTD=100 CTATSTID=0.0001 CTATGATD=0.0001 MEFFTATBOTD=0.25 MEFFTATSTID=0.25 MEFFTATGATD=0.25 CBBTBOT=1e-12 CBBTSTI=1e-21 CBBTGAT=1e-18 FBBTRBOT=1000000000 FBBTRSTI=1000000000 FBBTRGAT=1000000000 STFBBTBOT=-0.001 STFBBTSTI=-0.001 STFBBTGAT=-0.001 CBBTBOTD=1e-12 CBBTSTID=1e-18 CBBTGATD=1e-18 FBBTRBOTD=1000000000 FBBTRSTID=1000000000 FBBTRGATD=1000000000 STFBBTBOTD=-0.001 STFBBTSTID=-0.001 STFBBTGATD=-0.001 VBRBOT=10 VBRSTI=10 VBRGAT=10 PBRBOT=4 PBRSTI=4 PBRGAT=4 VBRBOTD=10 VBRSTID=10 VBRGATD=10 PBRBOTD=4 PBRSTID=4 PBRGATD=4 VJUNREF=2.5 FJUNQ=0.03 VJUNREFD=2.5 FJUNQD=0.03 RINT=0 RVPOLY=0 DLSIL=0 RSH=0 RSHD=0 CFRW=0 RSHG=40 RGO=15 RBULKO=347.5531852 RWELLO=173.7765926 RJUNSO=173.7765926 RJUNDO=173.7765926 SWSOA=0 VGS_MAX=3 VGD_MAX=3 VGB_MAX=3 VDS_MAX=3 VDB_MAX=1.6 VSB_MAX=1.6
model hvp_w2000n_l400n_ng1 PSP103VA TYPE=-1 TR=27 DTA=0 SWGEO=1 SWIGATE=1 SWIMPACT=1 SWGIDL=1 SWJUNCAP=3 SWJUNASYM=0 SWNUD=0 SWEDGE=0 SWDELVTAC=0 SWIGN=1 QMC=1 LVARO=-1.735e-09 LVARL=0 LVARW=0 LAP=3.471e-08 WVARO=0 WVARL=0 WVARW=0 WOT=0 DLQ=3.537e-08 DWQ=3e-08 VFBO=-1.0717 VFBL=-0.03 VFBW=0 VFBLW=0 STVFBO=0.00057379 STVFBL=8.6794e-05 STVFBW=4.9309e-05 STVFBLW=-3.6436e-05 ST2VFBO=0 TOXO=6.945e-09 EPSROXO=3.9 NSUBO=4.2268e+23 NSUBW=0.01112 WSEG=5.362e-08 NPCK=8.0711e+23 NPCKW=-0.011403 WSEGP=1e-06 LPCK=8.3733e-09 LPCKW=0.077499 FOL1=0.065253 FOL2=0.010199 FACNEFFACO=1 FACNEFFACL=0 FACNEFFACW=0 FACNEFFACLW=0 GFACNUDO=1 GFACNUDL=0 GFACNUDLEXP=1 GFACNUDW=0 GFACNUDLW=0 VSBNUDO=0 DVSBNUDO=1 VNSUBO=0 NSLPO=0.05 DNSUBO=0.03585 DPHIBO=-0.077884807 DPHIBL=0.00526388544 DPHIBLEXP=2.1893 DPHIBW=-0.011141504 DPHIBLW=-9.3915789e-05 DELVTACO=0 DELVTACL=0 DELVTACLEXP=1 DELVTACW=0 DELVTACLW=0 NPO=1.092e+26 NPL=0.2188 TOXOVO=6.945e-09 TOXOVDO=2e-09 LOV=3.471e-08 LOVD=0 NOVO=1.99e+26 NOVDO=5e+25 CTO=-0.006328 CTL=0 CTLEXP=1 CTW=0.3006 CTLW=-0.01196 CTGO=0 CTBO=0 STCTO=1 CFL=0.00045884 CFLEXP=2.2055 CFW=0.45909 CFBO=1 CFDO=0 PSCEL=0 PSCELEXP=2 PSCEW=0 PSCEBO=0 PSCEDO=0 UO=0.018428 FBET1=0.15952 FBET1W=-2.1872 LP1=9.9822e-08 LP1W=-1.0871 FBET2=-2.7066 LP2=5.8401e-08 BETW1=-0.097534 BETW2=0.022314 WBET=7.9844e-10 STBETO=1.6489 STBETL=0.029528 STBETW=0.037078 STBETLW=0.046991 MUEO=1.7444601 MUEW=-0.06367 STMUEO=1.0816 THEMUO=1.0324 STTHEMUO=0.26337 CSO=0.18648 CSL=0.21903 CSLEXP=2.0917 CSW=0.0072837 CSLW=0.02 STCSO=2 THECSO=2 STTHECSO=0 XCORO=0.001363 XCORL=8 XCORW=0.0060537 XCORLW=0.058951 STXCORO=-6.939e-18 FETAO=1.2853 RSW1=1970 RSW2=-0.057547 STRSO=-0.24812 RSBO=0.074639 RSGO=0.23490984 THESATO=8.4917e-05 THESATL=0.0067396 THESATLEXP=2.395 THESATW=1.1549 THESATLW=-0.01 STTHESATO=3.0405 STTHESATL=-0.16001 STTHESATW=-0.96988 STTHESATLW=0.36213 THESATBO=0.1 THESATGO=0.6304 AXO=16.822 AXL=3.0092 ALPL=0.0058454 ALPLEXP=0.47562 ALPW=-0.065973 ALP1L1=4.4409e-16 ALP1LEXP=1.347 ALP1L2=1 ALP1W=2 ALP2L1=3.6779e-06 ALP2LEXP=0.2531 ALP2L2=2.2204e-15 ALP2W=0.9582 VPO=1.8436e-06 A1O=47.788 A1L=0.029145 A1W=0.01435 A2O=38.581 STA2O=-0.0049931 A3O=1.1753 A3L=-0.069795 A3W=0.0032538 A4O=0.12593 A4L=-0.07 A4W=-0.04811 GCOO=0 IGINVLW=0 IGOVW=0 IGOVDW=0 STIGO=2 GC2O=0.375 GC3O=0.063 CHIBO=3.1 AGIDLW=6e-10 AGIDLDW=0 BGIDLO=5.5970304 BGIDLDO=41 STBGIDLO=-0.0049461 STBGIDLDO=0 CGIDLO=0.23693 CGIDLDO=0 CGBOVL=-4.669e-16 CFRDW=0 FNTO=1 FNTEXCL=0 NFALW=1.3e+25 NFBLW=5289000000 NFCLW=2e-07 EFO=1.152 LINTNOI=2.5e-08 ALPNOI=2 WEDGE=1e-08 WEDGEW=0 VFBEDGEO=-1 STVFBEDGEO=0.0005 STVFBEDGEL=0 STVFBEDGEW=0 STVFBEDGELW=0 DPHIBEDGEO=0 DPHIBEDGEL=0 DPHIBEDGELEXP=1 DPHIBEDGEW=0 DPHIBEDGELW=0 NSUBEDGEO=5e+23 NSUBEDGEL=0 NSUBEDGELEXP=1 NSUBEDGEW=0 NSUBEDGELW=0 CTEDGEO=0 CTEDGEL=0 CTEDGELEXP=1 FBETEDGE=0 LPEDGE=1e-08 BETEDGEW=0 STBETEDGEO=1 STBETEDGEL=0 STBETEDGEW=0 STBETEDGELW=0 PSCEEDGEL=0 PSCEEDGELEXP=2 PSCEEDGEW=0 PSCEBEDGEO=0 PSCEDEDGEO=0 CFEDGEL=0 CFEDGELEXP=2 CFEDGEW=0 CFDEDGEO=0 CFBEDGEO=0 FNTEDGEO=1 NFAEDGELW=8e+22 NFBEDGELW=30000000 NFCEDGELW=0 EFEDGEO=1 SAREF=1e-06 SBREF=1e-06 WLOD=0 KUO=0 KVSAT=0 TKUO=0 LKUO=0 WKUO=0 PKUO=0 LLODKUO=0 WLODKUO=0 KVTHO=0 LKVTHO=0 WKVTHO=0 PKVTHO=0 LLODVTH=0 WLODVTH=0 STETAO=0 LODETAO=1 SCREF=1e-06 WEB=0 WEC=0 KVTHOWEO=0 KVTHOWEL=0 KVTHOWEW=0 KVTHOWELW=0 KUOWEO=0 KUOWEL=0 KUOWEW=0 KUOWELW=0 TRJ=21 SWJUNEXP=0 IMAX=0.0024527 FREV=1000 CJORBOT=0.0008095 CJORSTI=4.2583e-11 CJORGAT=3.1e-11 VBIRBOT=0.72606 VBIRSTI=0.69819 VBIRGAT=1.199 PBOT=0.33078 PSTI=0.22409 PGAT=0.4474 CJORBOTD=0.001 CJORSTID=1e-09 CJORGATD=1e-09 VBIRBOTD=1 VBIRSTID=1 VBIRGATD=1 PBOTD=0.5 PSTID=0.5 PGATD=0.5 PHIGBOT=1.0641 PHIGSTI=1.3946 PHIGGAT=1.83 IDSATRBOT=3.0606e-08 IDSATRSTI=3.6127e-15 IDSATRGAT=0 CSRHBOT=100 CSRHSTI=0.0001 CSRHGAT=0.0001 XJUNSTI=4.93e-08 XJUNGAT=7.062e-07 PHIGBOTD=1.16 PHIGSTID=1.16 PHIGGATD=1.16 IDSATRBOTD=1e-12 IDSATRSTID=1e-18 IDSATRGATD=1e-18 CSRHBOTD=100 CSRHSTID=0.0001 CSRHGATD=0.0001 XJUNSTID=1e-07 XJUNGATD=1e-07 CTATBOT=100 CTATSTI=0.0001 CTATGAT=0.0001 MEFFTATBOT=0.25 MEFFTATSTI=0.25 MEFFTATGAT=0.25 CTATBOTD=100 CTATSTID=0.0001 CTATGATD=0.0001 MEFFTATBOTD=0.25 MEFFTATSTID=0.25 MEFFTATGATD=0.25 CBBTBOT=1e-12 CBBTSTI=1e-21 CBBTGAT=1e-18 FBBTRBOT=1000000000 FBBTRSTI=1000000000 FBBTRGAT=1000000000 STFBBTBOT=-0.001 STFBBTSTI=-0.001 STFBBTGAT=-0.001 CBBTBOTD=1e-12 CBBTSTID=1e-18 CBBTGATD=1e-18 FBBTRBOTD=1000000000 FBBTRSTID=1000000000 FBBTRGATD=1000000000 STFBBTBOTD=-0.001 STFBBTSTID=-0.001 STFBBTGATD=-0.001 VBRBOT=10 VBRSTI=10 VBRGAT=10 PBRBOT=4 PBRSTI=4 PBRGAT=4 VBRBOTD=10 VBRSTID=10 VBRGATD=10 PBRBOTD=4 PBRSTID=4 PBRGATD=4 VJUNREF=2.5 FJUNQ=0.03 VJUNREFD=2.5 FJUNQD=0.03 RINT=0 RVPOLY=0 DLSIL=0 RSH=0 RSHD=0 CFRW=0 RSHG=40 RGO=15 RBULKO=1000 RWELLO=500 RJUNSO=1000 RJUNDO=1000 SWSOA=0 VGS_MAX=3 VGD_MAX=3 VGB_MAX=3 VDS_MAX=3 VDB_MAX=1.6 VSB_MAX=1.6
model hvp_w2000n_l500n_ng1 PSP103VA TYPE=-1 TR=27 DTA=0 SWGEO=1 SWIGATE=1 SWIMPACT=1 SWGIDL=1 SWJUNCAP=3 SWJUNASYM=0 SWNUD=0 SWEDGE=0 SWDELVTAC=0 SWIGN=1 QMC=1 LVARO=-1.735e-09 LVARL=0 LVARW=0 LAP=3.471e-08 WVARO=0 WVARL=0 WVARW=0 WOT=0 DLQ=3.537e-08 DWQ=3e-08 VFBO=-1.0717 VFBL=-0.03 VFBW=0 VFBLW=0 STVFBO=0.00057379 STVFBL=8.6794e-05 STVFBW=4.9309e-05 STVFBLW=-3.6436e-05 ST2VFBO=0 TOXO=6.945e-09 EPSROXO=3.9 NSUBO=4.2268e+23 NSUBW=0.01112 WSEG=5.362e-08 NPCK=8.0711e+23 NPCKW=-0.011403 WSEGP=1e-06 LPCK=8.3733e-09 LPCKW=0.077499 FOL1=0.065253 FOL2=0.010199 FACNEFFACO=1 FACNEFFACL=0 FACNEFFACW=0 FACNEFFACLW=0 GFACNUDO=1 GFACNUDL=0 GFACNUDLEXP=1 GFACNUDW=0 GFACNUDLW=0 VSBNUDO=0 DVSBNUDO=1 VNSUBO=0 NSLPO=0.05 DNSUBO=0.03585 DPHIBO=-0.077884807 DPHIBL=0.00526388544 DPHIBLEXP=2.1893 DPHIBW=-0.011141504 DPHIBLW=-9.3915789e-05 DELVTACO=0 DELVTACL=0 DELVTACLEXP=1 DELVTACW=0 DELVTACLW=0 NPO=1.092e+26 NPL=0.2188 TOXOVO=6.945e-09 TOXOVDO=2e-09 LOV=3.471e-08 LOVD=0 NOVO=1.99e+26 NOVDO=5e+25 CTO=-0.006328 CTL=0 CTLEXP=1 CTW=0.3006 CTLW=-0.01196 CTGO=0 CTBO=0 STCTO=1 CFL=0.00045884 CFLEXP=2.2055 CFW=0.45909 CFBO=1 CFDO=0 PSCEL=0 PSCELEXP=2 PSCEW=0 PSCEBO=0 PSCEDO=0 UO=0.018428 FBET1=0.15952 FBET1W=-2.1872 LP1=9.9822e-08 LP1W=-1.0871 FBET2=-2.7066 LP2=5.8401e-08 BETW1=-0.097534 BETW2=0.022314 WBET=7.9844e-10 STBETO=1.6489 STBETL=0.029528 STBETW=0.037078 STBETLW=0.046991 MUEO=1.7444601 MUEW=-0.06367 STMUEO=1.0816 THEMUO=1.0324 STTHEMUO=0.26337 CSO=0.18648 CSL=0.21903 CSLEXP=2.0917 CSW=0.0072837 CSLW=0.02 STCSO=2 THECSO=2 STTHECSO=0 XCORO=0.001363 XCORL=8 XCORW=0.0060537 XCORLW=0.058951 STXCORO=-6.939e-18 FETAO=1.2853 RSW1=1970 RSW2=-0.057547 STRSO=-0.24812 RSBO=0.074639 RSGO=0.23490984 THESATO=8.4917e-05 THESATL=0.0067396 THESATLEXP=2.395 THESATW=1.1549 THESATLW=-0.01 STTHESATO=3.0405 STTHESATL=-0.16001 STTHESATW=-0.96988 STTHESATLW=0.36213 THESATBO=0.1 THESATGO=0.6304 AXO=16.822 AXL=3.0092 ALPL=0.0058454 ALPLEXP=0.47562 ALPW=-0.065973 ALP1L1=4.4409e-16 ALP1LEXP=1.347 ALP1L2=1 ALP1W=2 ALP2L1=3.6779e-06 ALP2LEXP=0.2531 ALP2L2=2.2204e-15 ALP2W=0.9582 VPO=1.8436e-06 A1O=47.788 A1L=0.029145 A1W=0.01435 A2O=38.581 STA2O=-0.0049931 A3O=1.1753 A3L=-0.069795 A3W=0.0032538 A4O=0.12593 A4L=-0.07 A4W=-0.04811 GCOO=0 IGINVLW=0 IGOVW=0 IGOVDW=0 STIGO=2 GC2O=0.375 GC3O=0.063 CHIBO=3.1 AGIDLW=6e-10 AGIDLDW=0 BGIDLO=5.5970304 BGIDLDO=41 STBGIDLO=-0.0049461 STBGIDLDO=0 CGIDLO=0.23693 CGIDLDO=0 CGBOVL=-4.669e-16 CFRDW=0 FNTO=1 FNTEXCL=0 NFALW=1.3e+25 NFBLW=5289000000 NFCLW=2e-07 EFO=1.152 LINTNOI=2.5e-08 ALPNOI=2 WEDGE=1e-08 WEDGEW=0 VFBEDGEO=-1 STVFBEDGEO=0.0005 STVFBEDGEL=0 STVFBEDGEW=0 STVFBEDGELW=0 DPHIBEDGEO=0 DPHIBEDGEL=0 DPHIBEDGELEXP=1 DPHIBEDGEW=0 DPHIBEDGELW=0 NSUBEDGEO=5e+23 NSUBEDGEL=0 NSUBEDGELEXP=1 NSUBEDGEW=0 NSUBEDGELW=0 CTEDGEO=0 CTEDGEL=0 CTEDGELEXP=1 FBETEDGE=0 LPEDGE=1e-08 BETEDGEW=0 STBETEDGEO=1 STBETEDGEL=0 STBETEDGEW=0 STBETEDGELW=0 PSCEEDGEL=0 PSCEEDGELEXP=2 PSCEEDGEW=0 PSCEBEDGEO=0 PSCEDEDGEO=0 CFEDGEL=0 CFEDGELEXP=2 CFEDGEW=0 CFDEDGEO=0 CFBEDGEO=0 FNTEDGEO=1 NFAEDGELW=8e+22 NFBEDGELW=30000000 NFCEDGELW=0 EFEDGEO=1 SAREF=1e-06 SBREF=1e-06 WLOD=0 KUO=0 KVSAT=0 TKUO=0 LKUO=0 WKUO=0 PKUO=0 LLODKUO=0 WLODKUO=0 KVTHO=0 LKVTHO=0 WKVTHO=0 PKVTHO=0 LLODVTH=0 WLODVTH=0 STETAO=0 LODETAO=1 SCREF=1e-06 WEB=0 WEC=0 KVTHOWEO=0 KVTHOWEL=0 KVTHOWEW=0 KVTHOWELW=0 KUOWEO=0 KUOWEL=0 KUOWEW=0 KUOWELW=0 TRJ=21 SWJUNEXP=0 IMAX=0.0024527 FREV=1000 CJORBOT=0.0008095 CJORSTI=4.2583e-11 CJORGAT=3.1e-11 VBIRBOT=0.72606 VBIRSTI=0.69819 VBIRGAT=1.199 PBOT=0.33078 PSTI=0.22409 PGAT=0.4474 CJORBOTD=0.001 CJORSTID=1e-09 CJORGATD=1e-09 VBIRBOTD=1 VBIRSTID=1 VBIRGATD=1 PBOTD=0.5 PSTID=0.5 PGATD=0.5 PHIGBOT=1.0641 PHIGSTI=1.3946 PHIGGAT=1.83 IDSATRBOT=3.0606e-08 IDSATRSTI=3.6127e-15 IDSATRGAT=0 CSRHBOT=100 CSRHSTI=0.0001 CSRHGAT=0.0001 XJUNSTI=4.93e-08 XJUNGAT=7.062e-07 PHIGBOTD=1.16 PHIGSTID=1.16 PHIGGATD=1.16 IDSATRBOTD=1e-12 IDSATRSTID=1e-18 IDSATRGATD=1e-18 CSRHBOTD=100 CSRHSTID=0.0001 CSRHGATD=0.0001 XJUNSTID=1e-07 XJUNGATD=1e-07 CTATBOT=100 CTATSTI=0.0001 CTATGAT=0.0001 MEFFTATBOT=0.25 MEFFTATSTI=0.25 MEFFTATGAT=0.25 CTATBOTD=100 CTATSTID=0.0001 CTATGATD=0.0001 MEFFTATBOTD=0.25 MEFFTATSTID=0.25 MEFFTATGATD=0.25 CBBTBOT=1e-12 CBBTSTI=1e-21 CBBTGAT=1e-18 FBBTRBOT=1000000000 FBBTRSTI=1000000000 FBBTRGAT=1000000000 STFBBTBOT=-0.001 STFBBTSTI=-0.001 STFBBTGAT=-0.001 CBBTBOTD=1e-12 CBBTSTID=1e-18 CBBTGATD=1e-18 FBBTRBOTD=1000000000 FBBTRSTID=1000000000 FBBTRGATD=1000000000 STFBBTBOTD=-0.001 STFBBTSTID=-0.001 STFBBTGATD=-0.001 VBRBOT=10 VBRSTI=10 VBRGAT=10 PBRBOT=4 PBRSTI=4 PBRGAT=4 VBRBOTD=10 VBRSTID=10 VBRGATD=10 PBRBOTD=4 PBRSTID=4 PBRGATD=4 VJUNREF=2.5 FJUNQ=0.03 VJUNREFD=2.5 FJUNQD=0.03 RINT=0 RVPOLY=0 DLSIL=0 RSH=0 RSHD=0 CFRW=0 RSHG=40 RGO=15 RBULKO=1000 RWELLO=500 RJUNSO=1250 RJUNDO=1250 SWSOA=0 VGS_MAX=3 VGD_MAX=3 VGB_MAX=3 VDS_MAX=3 VDB_MAX=1.6 VSB_MAX=1.6
model hvp_w20676n_l2000n_ng3 PSP103VA TYPE=-1 TR=27 DTA=0 SWGEO=1 SWIGATE=1 SWIMPACT=1 SWGIDL=1 SWJUNCAP=3 SWJUNASYM=0 SWNUD=0 SWEDGE=0 SWDELVTAC=0 SWIGN=1 QMC=1 LVARO=-1.735e-09 LVARL=0 LVARW=0 LAP=3.471e-08 WVARO=0 WVARL=0 WVARW=0 WOT=0 DLQ=3.537e-08 DWQ=3e-08 VFBO=-1.0717 VFBL=-0.03 VFBW=0 VFBLW=0 STVFBO=0.00057379 STVFBL=8.6794e-05 STVFBW=4.9309e-05 STVFBLW=-3.6436e-05 ST2VFBO=0 TOXO=6.945e-09 EPSROXO=3.9 NSUBO=4.2268e+23 NSUBW=0.01112 WSEG=5.362e-08 NPCK=8.0711e+23 NPCKW=-0.011403 WSEGP=1e-06 LPCK=8.3733e-09 LPCKW=0.077499 FOL1=0.065253 FOL2=0.010199 FACNEFFACO=1 FACNEFFACL=0 FACNEFFACW=0 FACNEFFACLW=0 GFACNUDO=1 GFACNUDL=0 GFACNUDLEXP=1 GFACNUDW=0 GFACNUDLW=0 VSBNUDO=0 DVSBNUDO=1 VNSUBO=0 NSLPO=0.05 DNSUBO=0.03585 DPHIBO=-0.077884807 DPHIBL=0.00526388544 DPHIBLEXP=2.1893 DPHIBW=-0.011141504 DPHIBLW=-9.3915789e-05 DELVTACO=0 DELVTACL=0 DELVTACLEXP=1 DELVTACW=0 DELVTACLW=0 NPO=1.092e+26 NPL=0.2188 TOXOVO=6.945e-09 TOXOVDO=2e-09 LOV=3.471e-08 LOVD=0 NOVO=1.99e+26 NOVDO=5e+25 CTO=-0.006328 CTL=0 CTLEXP=1 CTW=0.3006 CTLW=-0.01196 CTGO=0 CTBO=0 STCTO=1 CFL=0.00045884 CFLEXP=2.2055 CFW=0.45909 CFBO=1 CFDO=0 PSCEL=0 PSCELEXP=2 PSCEW=0 PSCEBO=0 PSCEDO=0 UO=0.018428 FBET1=0.15952 FBET1W=-2.1872 LP1=9.9822e-08 LP1W=-1.0871 FBET2=-2.7066 LP2=5.8401e-08 BETW1=-0.097534 BETW2=0.022314 WBET=7.9844e-10 STBETO=1.6489 STBETL=0.029528 STBETW=0.037078 STBETLW=0.046991 MUEO=1.7444601 MUEW=-0.06367 STMUEO=1.0816 THEMUO=1.0324 STTHEMUO=0.26337 CSO=0.18648 CSL=0.21903 CSLEXP=2.0917 CSW=0.0072837 CSLW=0.02 STCSO=2 THECSO=2 STTHECSO=0 XCORO=0.001363 XCORL=8 XCORW=0.0060537 XCORLW=0.058951 STXCORO=-6.939e-18 FETAO=1.2853 RSW1=1970 RSW2=-0.057547 STRSO=-0.24812 RSBO=0.074639 RSGO=0.23490984 THESATO=8.4917e-05 THESATL=0.0067396 THESATLEXP=2.395 THESATW=1.1549 THESATLW=-0.01 STTHESATO=3.0405 STTHESATL=-0.16001 STTHESATW=-0.96988 STTHESATLW=0.36213 THESATBO=0.1 THESATGO=0.6304 AXO=16.822 AXL=3.0092 ALPL=0.0058454 ALPLEXP=0.47562 ALPW=-0.065973 ALP1L1=4.4409e-16 ALP1LEXP=1.347 ALP1L2=1 ALP1W=2 ALP2L1=3.6779e-06 ALP2LEXP=0.2531 ALP2L2=2.2204e-15 ALP2W=0.9582 VPO=1.8436e-06 A1O=47.788 A1L=0.029145 A1W=0.01435 A2O=38.581 STA2O=-0.0049931 A3O=1.1753 A3L=-0.069795 A3W=0.0032538 A4O=0.12593 A4L=-0.07 A4W=-0.04811 GCOO=0 IGINVLW=0 IGOVW=0 IGOVDW=0 STIGO=2 GC2O=0.375 GC3O=0.063 CHIBO=3.1 AGIDLW=6e-10 AGIDLDW=0 BGIDLO=5.5970304 BGIDLDO=41 STBGIDLO=-0.0049461 STBGIDLDO=0 CGIDLO=0.23693 CGIDLDO=0 CGBOVL=-4.669e-16 CFRDW=0 FNTO=1 FNTEXCL=0 NFALW=1.3e+25 NFBLW=5289000000 NFCLW=2e-07 EFO=1.152 LINTNOI=2.5e-08 ALPNOI=2 WEDGE=1e-08 WEDGEW=0 VFBEDGEO=-1 STVFBEDGEO=0.0005 STVFBEDGEL=0 STVFBEDGEW=0 STVFBEDGELW=0 DPHIBEDGEO=0 DPHIBEDGEL=0 DPHIBEDGELEXP=1 DPHIBEDGEW=0 DPHIBEDGELW=0 NSUBEDGEO=5e+23 NSUBEDGEL=0 NSUBEDGELEXP=1 NSUBEDGEW=0 NSUBEDGELW=0 CTEDGEO=0 CTEDGEL=0 CTEDGELEXP=1 FBETEDGE=0 LPEDGE=1e-08 BETEDGEW=0 STBETEDGEO=1 STBETEDGEL=0 STBETEDGEW=0 STBETEDGELW=0 PSCEEDGEL=0 PSCEEDGELEXP=2 PSCEEDGEW=0 PSCEBEDGEO=0 PSCEDEDGEO=0 CFEDGEL=0 CFEDGELEXP=2 CFEDGEW=0 CFDEDGEO=0 CFBEDGEO=0 FNTEDGEO=1 NFAEDGELW=8e+22 NFBEDGELW=30000000 NFCEDGELW=0 EFEDGEO=1 SAREF=1e-06 SBREF=1e-06 WLOD=0 KUO=0 KVSAT=0 TKUO=0 LKUO=0 WKUO=0 PKUO=0 LLODKUO=0 WLODKUO=0 KVTHO=0 LKVTHO=0 WKVTHO=0 PKVTHO=0 LLODVTH=0 WLODVTH=0 STETAO=0 LODETAO=1 SCREF=1e-06 WEB=0 WEC=0 KVTHOWEO=0 KVTHOWEL=0 KVTHOWEW=0 KVTHOWELW=0 KUOWEO=0 KUOWEL=0 KUOWEW=0 KUOWELW=0 TRJ=21 SWJUNEXP=0 IMAX=0.0024527 FREV=1000 CJORBOT=0.0008095 CJORSTI=4.2583e-11 CJORGAT=3.1e-11 VBIRBOT=0.72606 VBIRSTI=0.69819 VBIRGAT=1.199 PBOT=0.33078 PSTI=0.22409 PGAT=0.4474 CJORBOTD=0.001 CJORSTID=1e-09 CJORGATD=1e-09 VBIRBOTD=1 VBIRSTID=1 VBIRGATD=1 PBOTD=0.5 PSTID=0.5 PGATD=0.5 PHIGBOT=1.0641 PHIGSTI=1.3946 PHIGGAT=1.83 IDSATRBOT=3.0606e-08 IDSATRSTI=3.6127e-15 IDSATRGAT=0 CSRHBOT=100 CSRHSTI=0.0001 CSRHGAT=0.0001 XJUNSTI=4.93e-08 XJUNGAT=7.062e-07 PHIGBOTD=1.16 PHIGSTID=1.16 PHIGGATD=1.16 IDSATRBOTD=1e-12 IDSATRSTID=1e-18 IDSATRGATD=1e-18 CSRHBOTD=100 CSRHSTID=0.0001 CSRHGATD=0.0001 XJUNSTID=1e-07 XJUNGATD=1e-07 CTATBOT=100 CTATSTI=0.0001 CTATGAT=0.0001 MEFFTATBOT=0.25 MEFFTATSTI=0.25 MEFFTATGAT=0.25 CTATBOTD=100 CTATSTID=0.0001 CTATGATD=0.0001 MEFFTATBOTD=0.25 MEFFTATSTID=0.25 MEFFTATGATD=0.25 CBBTBOT=1e-12 CBBTSTI=1e-21 CBBTGAT=1e-18 FBBTRBOT=1000000000 FBBTRSTI=1000000000 FBBTRGAT=1000000000 STFBBTBOT=-0.001 STFBBTSTI=-0.001 STFBBTGAT=-0.001 CBBTBOTD=1e-12 CBBTSTID=1e-18 CBBTGATD=1e-18 FBBTRBOTD=1000000000 FBBTRSTID=1000000000 FBBTRGATD=1000000000 STFBBTBOTD=-0.001 STFBBTSTID=-0.001 STFBBTGATD=-0.001 VBRBOT=10 VBRSTI=10 VBRGAT=10 PBRBOT=4 PBRSTI=4 PBRGAT=4 VBRBOTD=10 VBRSTID=10 VBRGATD=10 PBRBOTD=4 PBRSTID=4 PBRGATD=4 VJUNREF=2.5 FJUNQ=0.03 VJUNREFD=2.5 FJUNQD=0.03 RINT=0 RVPOLY=0 DLSIL=0 RSH=0 RSHD=0 CFRW=0 RSHG=40 RGO=15 RBULKO=290.1922685 RWELLO=145.0961342 RJUNSO=483.6537808 RJUNDO=483.6537808 SWSOA=0 VGS_MAX=3 VGD_MAX=3 VGB_MAX=3 VDS_MAX=3 VDB_MAX=1.6 VSB_MAX=1.6
model hvp_w21753n_l2000n_ng3 PSP103VA TYPE=-1 TR=27 DTA=0 SWGEO=1 SWIGATE=1 SWIMPACT=1 SWGIDL=1 SWJUNCAP=3 SWJUNASYM=0 SWNUD=0 SWEDGE=0 SWDELVTAC=0 SWIGN=1 QMC=1 LVARO=-1.735e-09 LVARL=0 LVARW=0 LAP=3.471e-08 WVARO=0 WVARL=0 WVARW=0 WOT=0 DLQ=3.537e-08 DWQ=3e-08 VFBO=-1.0717 VFBL=-0.03 VFBW=0 VFBLW=0 STVFBO=0.00057379 STVFBL=8.6794e-05 STVFBW=4.9309e-05 STVFBLW=-3.6436e-05 ST2VFBO=0 TOXO=6.945e-09 EPSROXO=3.9 NSUBO=4.2268e+23 NSUBW=0.01112 WSEG=5.362e-08 NPCK=8.0711e+23 NPCKW=-0.011403 WSEGP=1e-06 LPCK=8.3733e-09 LPCKW=0.077499 FOL1=0.065253 FOL2=0.010199 FACNEFFACO=1 FACNEFFACL=0 FACNEFFACW=0 FACNEFFACLW=0 GFACNUDO=1 GFACNUDL=0 GFACNUDLEXP=1 GFACNUDW=0 GFACNUDLW=0 VSBNUDO=0 DVSBNUDO=1 VNSUBO=0 NSLPO=0.05 DNSUBO=0.03585 DPHIBO=-0.077884807 DPHIBL=0.00526388544 DPHIBLEXP=2.1893 DPHIBW=-0.011141504 DPHIBLW=-9.3915789e-05 DELVTACO=0 DELVTACL=0 DELVTACLEXP=1 DELVTACW=0 DELVTACLW=0 NPO=1.092e+26 NPL=0.2188 TOXOVO=6.945e-09 TOXOVDO=2e-09 LOV=3.471e-08 LOVD=0 NOVO=1.99e+26 NOVDO=5e+25 CTO=-0.006328 CTL=0 CTLEXP=1 CTW=0.3006 CTLW=-0.01196 CTGO=0 CTBO=0 STCTO=1 CFL=0.00045884 CFLEXP=2.2055 CFW=0.45909 CFBO=1 CFDO=0 PSCEL=0 PSCELEXP=2 PSCEW=0 PSCEBO=0 PSCEDO=0 UO=0.018428 FBET1=0.15952 FBET1W=-2.1872 LP1=9.9822e-08 LP1W=-1.0871 FBET2=-2.7066 LP2=5.8401e-08 BETW1=-0.097534 BETW2=0.022314 WBET=7.9844e-10 STBETO=1.6489 STBETL=0.029528 STBETW=0.037078 STBETLW=0.046991 MUEO=1.7444601 MUEW=-0.06367 STMUEO=1.0816 THEMUO=1.0324 STTHEMUO=0.26337 CSO=0.18648 CSL=0.21903 CSLEXP=2.0917 CSW=0.0072837 CSLW=0.02 STCSO=2 THECSO=2 STTHECSO=0 XCORO=0.001363 XCORL=8 XCORW=0.0060537 XCORLW=0.058951 STXCORO=-6.939e-18 FETAO=1.2853 RSW1=1970 RSW2=-0.057547 STRSO=-0.24812 RSBO=0.074639 RSGO=0.23490984 THESATO=8.4917e-05 THESATL=0.0067396 THESATLEXP=2.395 THESATW=1.1549 THESATLW=-0.01 STTHESATO=3.0405 STTHESATL=-0.16001 STTHESATW=-0.96988 STTHESATLW=0.36213 THESATBO=0.1 THESATGO=0.6304 AXO=16.822 AXL=3.0092 ALPL=0.0058454 ALPLEXP=0.47562 ALPW=-0.065973 ALP1L1=4.4409e-16 ALP1LEXP=1.347 ALP1L2=1 ALP1W=2 ALP2L1=3.6779e-06 ALP2LEXP=0.2531 ALP2L2=2.2204e-15 ALP2W=0.9582 VPO=1.8436e-06 A1O=47.788 A1L=0.029145 A1W=0.01435 A2O=38.581 STA2O=-0.0049931 A3O=1.1753 A3L=-0.069795 A3W=0.0032538 A4O=0.12593 A4L=-0.07 A4W=-0.04811 GCOO=0 IGINVLW=0 IGOVW=0 IGOVDW=0 STIGO=2 GC2O=0.375 GC3O=0.063 CHIBO=3.1 AGIDLW=6e-10 AGIDLDW=0 BGIDLO=5.5970304 BGIDLDO=41 STBGIDLO=-0.0049461 STBGIDLDO=0 CGIDLO=0.23693 CGIDLDO=0 CGBOVL=-4.669e-16 CFRDW=0 FNTO=1 FNTEXCL=0 NFALW=1.3e+25 NFBLW=5289000000 NFCLW=2e-07 EFO=1.152 LINTNOI=2.5e-08 ALPNOI=2 WEDGE=1e-08 WEDGEW=0 VFBEDGEO=-1 STVFBEDGEO=0.0005 STVFBEDGEL=0 STVFBEDGEW=0 STVFBEDGELW=0 DPHIBEDGEO=0 DPHIBEDGEL=0 DPHIBEDGELEXP=1 DPHIBEDGEW=0 DPHIBEDGELW=0 NSUBEDGEO=5e+23 NSUBEDGEL=0 NSUBEDGELEXP=1 NSUBEDGEW=0 NSUBEDGELW=0 CTEDGEO=0 CTEDGEL=0 CTEDGELEXP=1 FBETEDGE=0 LPEDGE=1e-08 BETEDGEW=0 STBETEDGEO=1 STBETEDGEL=0 STBETEDGEW=0 STBETEDGELW=0 PSCEEDGEL=0 PSCEEDGELEXP=2 PSCEEDGEW=0 PSCEBEDGEO=0 PSCEDEDGEO=0 CFEDGEL=0 CFEDGELEXP=2 CFEDGEW=0 CFDEDGEO=0 CFBEDGEO=0 FNTEDGEO=1 NFAEDGELW=8e+22 NFBEDGELW=30000000 NFCEDGELW=0 EFEDGEO=1 SAREF=1e-06 SBREF=1e-06 WLOD=0 KUO=0 KVSAT=0 TKUO=0 LKUO=0 WKUO=0 PKUO=0 LLODKUO=0 WLODKUO=0 KVTHO=0 LKVTHO=0 WKVTHO=0 PKVTHO=0 LLODVTH=0 WLODVTH=0 STETAO=0 LODETAO=1 SCREF=1e-06 WEB=0 WEC=0 KVTHOWEO=0 KVTHOWEL=0 KVTHOWEW=0 KVTHOWELW=0 KUOWEO=0 KUOWEL=0 KUOWEW=0 KUOWELW=0 TRJ=21 SWJUNEXP=0 IMAX=0.0024527 FREV=1000 CJORBOT=0.0008095 CJORSTI=4.2583e-11 CJORGAT=3.1e-11 VBIRBOT=0.72606 VBIRSTI=0.69819 VBIRGAT=1.199 PBOT=0.33078 PSTI=0.22409 PGAT=0.4474 CJORBOTD=0.001 CJORSTID=1e-09 CJORGATD=1e-09 VBIRBOTD=1 VBIRSTID=1 VBIRGATD=1 PBOTD=0.5 PSTID=0.5 PGATD=0.5 PHIGBOT=1.0641 PHIGSTI=1.3946 PHIGGAT=1.83 IDSATRBOT=3.0606e-08 IDSATRSTI=3.6127e-15 IDSATRGAT=0 CSRHBOT=100 CSRHSTI=0.0001 CSRHGAT=0.0001 XJUNSTI=4.93e-08 XJUNGAT=7.062e-07 PHIGBOTD=1.16 PHIGSTID=1.16 PHIGGATD=1.16 IDSATRBOTD=1e-12 IDSATRSTID=1e-18 IDSATRGATD=1e-18 CSRHBOTD=100 CSRHSTID=0.0001 CSRHGATD=0.0001 XJUNSTID=1e-07 XJUNGATD=1e-07 CTATBOT=100 CTATSTI=0.0001 CTATGAT=0.0001 MEFFTATBOT=0.25 MEFFTATSTI=0.25 MEFFTATGAT=0.25 CTATBOTD=100 CTATSTID=0.0001 CTATGATD=0.0001 MEFFTATBOTD=0.25 MEFFTATSTID=0.25 MEFFTATGATD=0.25 CBBTBOT=1e-12 CBBTSTI=1e-21 CBBTGAT=1e-18 FBBTRBOT=1000000000 FBBTRSTI=1000000000 FBBTRGAT=1000000000 STFBBTBOT=-0.001 STFBBTSTI=-0.001 STFBBTGAT=-0.001 CBBTBOTD=1e-12 CBBTSTID=1e-18 CBBTGATD=1e-18 FBBTRBOTD=1000000000 FBBTRSTID=1000000000 FBBTRGATD=1000000000 STFBBTBOTD=-0.001 STFBBTSTID=-0.001 STFBBTGATD=-0.001 VBRBOT=10 VBRSTI=10 VBRGAT=10 PBRBOT=4 PBRSTI=4 PBRGAT=4 VBRBOTD=10 VBRSTID=10 VBRGATD=10 PBRBOTD=4 PBRSTID=4 PBRGATD=4 VJUNREF=2.5 FJUNQ=0.03 VJUNREFD=2.5 FJUNQD=0.03 RINT=0 RVPOLY=0 DLSIL=0 RSH=0 RSHD=0 CFRW=0 RSHG=40 RGO=15 RBULKO=275.8259828 RWELLO=137.9129914 RJUNSO=459.7099713 RJUNDO=459.7099713 SWSOA=0 VGS_MAX=3 VGD_MAX=3 VGB_MAX=3 VDS_MAX=3 VDB_MAX=1.6 VSB_MAX=1.6
model hvp_w22635n_l2000n_ng3 PSP103VA TYPE=-1 TR=27 DTA=0 SWGEO=1 SWIGATE=1 SWIMPACT=1 SWGIDL=1 SWJUNCAP=3 SWJUNASYM=0 SWNUD=0 SWEDGE=0 SWDELVTAC=0 SWIGN=1 QMC=1 LVARO=-1.735e-09 LVARL=0 LVARW=0 LAP=3.471e-08 WVARO=0 WVARL=0 WVARW=0 WOT=0 DLQ=3.537e-08 DWQ=3e-08 VFBO=-1.0717 VFBL=-0.03 VFBW=0 VFBLW=0 STVFBO=0.00057379 STVFBL=8.6794e-05 STVFBW=4.9309e-05 STVFBLW=-3.6436e-05 ST2VFBO=0 TOXO=6.945e-09 EPSROXO=3.9 NSUBO=4.2268e+23 NSUBW=0.01112 WSEG=5.362e-08 NPCK=8.0711e+23 NPCKW=-0.011403 WSEGP=1e-06 LPCK=8.3733e-09 LPCKW=0.077499 FOL1=0.065253 FOL2=0.010199 FACNEFFACO=1 FACNEFFACL=0 FACNEFFACW=0 FACNEFFACLW=0 GFACNUDO=1 GFACNUDL=0 GFACNUDLEXP=1 GFACNUDW=0 GFACNUDLW=0 VSBNUDO=0 DVSBNUDO=1 VNSUBO=0 NSLPO=0.05 DNSUBO=0.03585 DPHIBO=-0.077884807 DPHIBL=0.00526388544 DPHIBLEXP=2.1893 DPHIBW=-0.011141504 DPHIBLW=-9.3915789e-05 DELVTACO=0 DELVTACL=0 DELVTACLEXP=1 DELVTACW=0 DELVTACLW=0 NPO=1.092e+26 NPL=0.2188 TOXOVO=6.945e-09 TOXOVDO=2e-09 LOV=3.471e-08 LOVD=0 NOVO=1.99e+26 NOVDO=5e+25 CTO=-0.006328 CTL=0 CTLEXP=1 CTW=0.3006 CTLW=-0.01196 CTGO=0 CTBO=0 STCTO=1 CFL=0.00045884 CFLEXP=2.2055 CFW=0.45909 CFBO=1 CFDO=0 PSCEL=0 PSCELEXP=2 PSCEW=0 PSCEBO=0 PSCEDO=0 UO=0.018428 FBET1=0.15952 FBET1W=-2.1872 LP1=9.9822e-08 LP1W=-1.0871 FBET2=-2.7066 LP2=5.8401e-08 BETW1=-0.097534 BETW2=0.022314 WBET=7.9844e-10 STBETO=1.6489 STBETL=0.029528 STBETW=0.037078 STBETLW=0.046991 MUEO=1.7444601 MUEW=-0.06367 STMUEO=1.0816 THEMUO=1.0324 STTHEMUO=0.26337 CSO=0.18648 CSL=0.21903 CSLEXP=2.0917 CSW=0.0072837 CSLW=0.02 STCSO=2 THECSO=2 STTHECSO=0 XCORO=0.001363 XCORL=8 XCORW=0.0060537 XCORLW=0.058951 STXCORO=-6.939e-18 FETAO=1.2853 RSW1=1970 RSW2=-0.057547 STRSO=-0.24812 RSBO=0.074639 RSGO=0.23490984 THESATO=8.4917e-05 THESATL=0.0067396 THESATLEXP=2.395 THESATW=1.1549 THESATLW=-0.01 STTHESATO=3.0405 STTHESATL=-0.16001 STTHESATW=-0.96988 STTHESATLW=0.36213 THESATBO=0.1 THESATGO=0.6304 AXO=16.822 AXL=3.0092 ALPL=0.0058454 ALPLEXP=0.47562 ALPW=-0.065973 ALP1L1=4.4409e-16 ALP1LEXP=1.347 ALP1L2=1 ALP1W=2 ALP2L1=3.6779e-06 ALP2LEXP=0.2531 ALP2L2=2.2204e-15 ALP2W=0.9582 VPO=1.8436e-06 A1O=47.788 A1L=0.029145 A1W=0.01435 A2O=38.581 STA2O=-0.0049931 A3O=1.1753 A3L=-0.069795 A3W=0.0032538 A4O=0.12593 A4L=-0.07 A4W=-0.04811 GCOO=0 IGINVLW=0 IGOVW=0 IGOVDW=0 STIGO=2 GC2O=0.375 GC3O=0.063 CHIBO=3.1 AGIDLW=6e-10 AGIDLDW=0 BGIDLO=5.5970304 BGIDLDO=41 STBGIDLO=-0.0049461 STBGIDLDO=0 CGIDLO=0.23693 CGIDLDO=0 CGBOVL=-4.669e-16 CFRDW=0 FNTO=1 FNTEXCL=0 NFALW=1.3e+25 NFBLW=5289000000 NFCLW=2e-07 EFO=1.152 LINTNOI=2.5e-08 ALPNOI=2 WEDGE=1e-08 WEDGEW=0 VFBEDGEO=-1 STVFBEDGEO=0.0005 STVFBEDGEL=0 STVFBEDGEW=0 STVFBEDGELW=0 DPHIBEDGEO=0 DPHIBEDGEL=0 DPHIBEDGELEXP=1 DPHIBEDGEW=0 DPHIBEDGELW=0 NSUBEDGEO=5e+23 NSUBEDGEL=0 NSUBEDGELEXP=1 NSUBEDGEW=0 NSUBEDGELW=0 CTEDGEO=0 CTEDGEL=0 CTEDGELEXP=1 FBETEDGE=0 LPEDGE=1e-08 BETEDGEW=0 STBETEDGEO=1 STBETEDGEL=0 STBETEDGEW=0 STBETEDGELW=0 PSCEEDGEL=0 PSCEEDGELEXP=2 PSCEEDGEW=0 PSCEBEDGEO=0 PSCEDEDGEO=0 CFEDGEL=0 CFEDGELEXP=2 CFEDGEW=0 CFDEDGEO=0 CFBEDGEO=0 FNTEDGEO=1 NFAEDGELW=8e+22 NFBEDGELW=30000000 NFCEDGELW=0 EFEDGEO=1 SAREF=1e-06 SBREF=1e-06 WLOD=0 KUO=0 KVSAT=0 TKUO=0 LKUO=0 WKUO=0 PKUO=0 LLODKUO=0 WLODKUO=0 KVTHO=0 LKVTHO=0 WKVTHO=0 PKVTHO=0 LLODVTH=0 WLODVTH=0 STETAO=0 LODETAO=1 SCREF=1e-06 WEB=0 WEC=0 KVTHOWEO=0 KVTHOWEL=0 KVTHOWEW=0 KVTHOWELW=0 KUOWEO=0 KUOWEL=0 KUOWEW=0 KUOWELW=0 TRJ=21 SWJUNEXP=0 IMAX=0.0024527 FREV=1000 CJORBOT=0.0008095 CJORSTI=4.2583e-11 CJORGAT=3.1e-11 VBIRBOT=0.72606 VBIRSTI=0.69819 VBIRGAT=1.199 PBOT=0.33078 PSTI=0.22409 PGAT=0.4474 CJORBOTD=0.001 CJORSTID=1e-09 CJORGATD=1e-09 VBIRBOTD=1 VBIRSTID=1 VBIRGATD=1 PBOTD=0.5 PSTID=0.5 PGATD=0.5 PHIGBOT=1.0641 PHIGSTI=1.3946 PHIGGAT=1.83 IDSATRBOT=3.0606e-08 IDSATRSTI=3.6127e-15 IDSATRGAT=0 CSRHBOT=100 CSRHSTI=0.0001 CSRHGAT=0.0001 XJUNSTI=4.93e-08 XJUNGAT=7.062e-07 PHIGBOTD=1.16 PHIGSTID=1.16 PHIGGATD=1.16 IDSATRBOTD=1e-12 IDSATRSTID=1e-18 IDSATRGATD=1e-18 CSRHBOTD=100 CSRHSTID=0.0001 CSRHGATD=0.0001 XJUNSTID=1e-07 XJUNGATD=1e-07 CTATBOT=100 CTATSTI=0.0001 CTATGAT=0.0001 MEFFTATBOT=0.25 MEFFTATSTI=0.25 MEFFTATGAT=0.25 CTATBOTD=100 CTATSTID=0.0001 CTATGATD=0.0001 MEFFTATBOTD=0.25 MEFFTATSTID=0.25 MEFFTATGATD=0.25 CBBTBOT=1e-12 CBBTSTI=1e-21 CBBTGAT=1e-18 FBBTRBOT=1000000000 FBBTRSTI=1000000000 FBBTRGAT=1000000000 STFBBTBOT=-0.001 STFBBTSTI=-0.001 STFBBTGAT=-0.001 CBBTBOTD=1e-12 CBBTSTID=1e-18 CBBTGATD=1e-18 FBBTRBOTD=1000000000 FBBTRSTID=1000000000 FBBTRGATD=1000000000 STFBBTBOTD=-0.001 STFBBTSTID=-0.001 STFBBTGATD=-0.001 VBRBOT=10 VBRSTI=10 VBRGAT=10 PBRBOT=4 PBRSTI=4 PBRGAT=4 VBRBOTD=10 VBRSTID=10 VBRGATD=10 PBRBOTD=4 PBRSTID=4 PBRGATD=4 VJUNREF=2.5 FJUNQ=0.03 VJUNREFD=2.5 FJUNQD=0.03 RINT=0 RVPOLY=0 DLSIL=0 RSH=0 RSHD=0 CFRW=0 RSHG=40 RGO=15 RBULKO=265.0736435 RWELLO=132.5368217 RJUNSO=441.7894058 RJUNDO=441.7894058 SWSOA=0 VGS_MAX=3 VGD_MAX=3 VGB_MAX=3 VDS_MAX=3 VDB_MAX=1.6 VSB_MAX=1.6
model hvp_w24000n_l2000n_ng3 PSP103VA TYPE=-1 TR=27 DTA=0 SWGEO=1 SWIGATE=1 SWIMPACT=1 SWGIDL=1 SWJUNCAP=3 SWJUNASYM=0 SWNUD=0 SWEDGE=0 SWDELVTAC=0 SWIGN=1 QMC=1 LVARO=-1.735e-09 LVARL=0 LVARW=0 LAP=3.471e-08 WVARO=0 WVARL=0 WVARW=0 WOT=0 DLQ=3.537e-08 DWQ=3e-08 VFBO=-1.0717 VFBL=-0.03 VFBW=0 VFBLW=0 STVFBO=0.00057379 STVFBL=8.6794e-05 STVFBW=4.9309e-05 STVFBLW=-3.6436e-05 ST2VFBO=0 TOXO=6.945e-09 EPSROXO=3.9 NSUBO=4.2268e+23 NSUBW=0.01112 WSEG=5.362e-08 NPCK=8.0711e+23 NPCKW=-0.011403 WSEGP=1e-06 LPCK=8.3733e-09 LPCKW=0.077499 FOL1=0.065253 FOL2=0.010199 FACNEFFACO=1 FACNEFFACL=0 FACNEFFACW=0 FACNEFFACLW=0 GFACNUDO=1 GFACNUDL=0 GFACNUDLEXP=1 GFACNUDW=0 GFACNUDLW=0 VSBNUDO=0 DVSBNUDO=1 VNSUBO=0 NSLPO=0.05 DNSUBO=0.03585 DPHIBO=-0.077884807 DPHIBL=0.00526388544 DPHIBLEXP=2.1893 DPHIBW=-0.011141504 DPHIBLW=-9.3915789e-05 DELVTACO=0 DELVTACL=0 DELVTACLEXP=1 DELVTACW=0 DELVTACLW=0 NPO=1.092e+26 NPL=0.2188 TOXOVO=6.945e-09 TOXOVDO=2e-09 LOV=3.471e-08 LOVD=0 NOVO=1.99e+26 NOVDO=5e+25 CTO=-0.006328 CTL=0 CTLEXP=1 CTW=0.3006 CTLW=-0.01196 CTGO=0 CTBO=0 STCTO=1 CFL=0.00045884 CFLEXP=2.2055 CFW=0.45909 CFBO=1 CFDO=0 PSCEL=0 PSCELEXP=2 PSCEW=0 PSCEBO=0 PSCEDO=0 UO=0.018428 FBET1=0.15952 FBET1W=-2.1872 LP1=9.9822e-08 LP1W=-1.0871 FBET2=-2.7066 LP2=5.8401e-08 BETW1=-0.097534 BETW2=0.022314 WBET=7.9844e-10 STBETO=1.6489 STBETL=0.029528 STBETW=0.037078 STBETLW=0.046991 MUEO=1.7444601 MUEW=-0.06367 STMUEO=1.0816 THEMUO=1.0324 STTHEMUO=0.26337 CSO=0.18648 CSL=0.21903 CSLEXP=2.0917 CSW=0.0072837 CSLW=0.02 STCSO=2 THECSO=2 STTHECSO=0 XCORO=0.001363 XCORL=8 XCORW=0.0060537 XCORLW=0.058951 STXCORO=-6.939e-18 FETAO=1.2853 RSW1=1970 RSW2=-0.057547 STRSO=-0.24812 RSBO=0.074639 RSGO=0.23490984 THESATO=8.4917e-05 THESATL=0.0067396 THESATLEXP=2.395 THESATW=1.1549 THESATLW=-0.01 STTHESATO=3.0405 STTHESATL=-0.16001 STTHESATW=-0.96988 STTHESATLW=0.36213 THESATBO=0.1 THESATGO=0.6304 AXO=16.822 AXL=3.0092 ALPL=0.0058454 ALPLEXP=0.47562 ALPW=-0.065973 ALP1L1=4.4409e-16 ALP1LEXP=1.347 ALP1L2=1 ALP1W=2 ALP2L1=3.6779e-06 ALP2LEXP=0.2531 ALP2L2=2.2204e-15 ALP2W=0.9582 VPO=1.8436e-06 A1O=47.788 A1L=0.029145 A1W=0.01435 A2O=38.581 STA2O=-0.0049931 A3O=1.1753 A3L=-0.069795 A3W=0.0032538 A4O=0.12593 A4L=-0.07 A4W=-0.04811 GCOO=0 IGINVLW=0 IGOVW=0 IGOVDW=0 STIGO=2 GC2O=0.375 GC3O=0.063 CHIBO=3.1 AGIDLW=6e-10 AGIDLDW=0 BGIDLO=5.5970304 BGIDLDO=41 STBGIDLO=-0.0049461 STBGIDLDO=0 CGIDLO=0.23693 CGIDLDO=0 CGBOVL=-4.669e-16 CFRDW=0 FNTO=1 FNTEXCL=0 NFALW=1.3e+25 NFBLW=5289000000 NFCLW=2e-07 EFO=1.152 LINTNOI=2.5e-08 ALPNOI=2 WEDGE=1e-08 WEDGEW=0 VFBEDGEO=-1 STVFBEDGEO=0.0005 STVFBEDGEL=0 STVFBEDGEW=0 STVFBEDGELW=0 DPHIBEDGEO=0 DPHIBEDGEL=0 DPHIBEDGELEXP=1 DPHIBEDGEW=0 DPHIBEDGELW=0 NSUBEDGEO=5e+23 NSUBEDGEL=0 NSUBEDGELEXP=1 NSUBEDGEW=0 NSUBEDGELW=0 CTEDGEO=0 CTEDGEL=0 CTEDGELEXP=1 FBETEDGE=0 LPEDGE=1e-08 BETEDGEW=0 STBETEDGEO=1 STBETEDGEL=0 STBETEDGEW=0 STBETEDGELW=0 PSCEEDGEL=0 PSCEEDGELEXP=2 PSCEEDGEW=0 PSCEBEDGEO=0 PSCEDEDGEO=0 CFEDGEL=0 CFEDGELEXP=2 CFEDGEW=0 CFDEDGEO=0 CFBEDGEO=0 FNTEDGEO=1 NFAEDGELW=8e+22 NFBEDGELW=30000000 NFCEDGELW=0 EFEDGEO=1 SAREF=1e-06 SBREF=1e-06 WLOD=0 KUO=0 KVSAT=0 TKUO=0 LKUO=0 WKUO=0 PKUO=0 LLODKUO=0 WLODKUO=0 KVTHO=0 LKVTHO=0 WKVTHO=0 PKVTHO=0 LLODVTH=0 WLODVTH=0 STETAO=0 LODETAO=1 SCREF=1e-06 WEB=0 WEC=0 KVTHOWEO=0 KVTHOWEL=0 KVTHOWEW=0 KVTHOWELW=0 KUOWEO=0 KUOWEL=0 KUOWEW=0 KUOWELW=0 TRJ=21 SWJUNEXP=0 IMAX=0.0024527 FREV=1000 CJORBOT=0.0008095 CJORSTI=4.2583e-11 CJORGAT=3.1e-11 VBIRBOT=0.72606 VBIRSTI=0.69819 VBIRGAT=1.199 PBOT=0.33078 PSTI=0.22409 PGAT=0.4474 CJORBOTD=0.001 CJORSTID=1e-09 CJORGATD=1e-09 VBIRBOTD=1 VBIRSTID=1 VBIRGATD=1 PBOTD=0.5 PSTID=0.5 PGATD=0.5 PHIGBOT=1.0641 PHIGSTI=1.3946 PHIGGAT=1.83 IDSATRBOT=3.0606e-08 IDSATRSTI=3.6127e-15 IDSATRGAT=0 CSRHBOT=100 CSRHSTI=0.0001 CSRHGAT=0.0001 XJUNSTI=4.93e-08 XJUNGAT=7.062e-07 PHIGBOTD=1.16 PHIGSTID=1.16 PHIGGATD=1.16 IDSATRBOTD=1e-12 IDSATRSTID=1e-18 IDSATRGATD=1e-18 CSRHBOTD=100 CSRHSTID=0.0001 CSRHGATD=0.0001 XJUNSTID=1e-07 XJUNGATD=1e-07 CTATBOT=100 CTATSTI=0.0001 CTATGAT=0.0001 MEFFTATBOT=0.25 MEFFTATSTI=0.25 MEFFTATGAT=0.25 CTATBOTD=100 CTATSTID=0.0001 CTATGATD=0.0001 MEFFTATBOTD=0.25 MEFFTATSTID=0.25 MEFFTATGATD=0.25 CBBTBOT=1e-12 CBBTSTI=1e-21 CBBTGAT=1e-18 FBBTRBOT=1000000000 FBBTRSTI=1000000000 FBBTRGAT=1000000000 STFBBTBOT=-0.001 STFBBTSTI=-0.001 STFBBTGAT=-0.001 CBBTBOTD=1e-12 CBBTSTID=1e-18 CBBTGATD=1e-18 FBBTRBOTD=1000000000 FBBTRSTID=1000000000 FBBTRGATD=1000000000 STFBBTBOTD=-0.001 STFBBTSTID=-0.001 STFBBTGATD=-0.001 VBRBOT=10 VBRSTI=10 VBRGAT=10 PBRBOT=4 PBRSTI=4 PBRGAT=4 VBRBOTD=10 VBRSTID=10 VBRGATD=10 PBRBOTD=4 PBRSTID=4 PBRGATD=4 VJUNREF=2.5 FJUNQ=0.03 VJUNREFD=2.5 FJUNQD=0.03 RINT=0 RVPOLY=0 DLSIL=0 RSH=0 RSHD=0 CFRW=0 RSHG=40 RGO=15 RBULKO=250 RWELLO=125 RJUNSO=416.6666667 RJUNDO=416.6666667 SWSOA=0 VGS_MAX=3 VGD_MAX=3 VGB_MAX=3 VDS_MAX=3 VDB_MAX=1.6 VSB_MAX=1.6
model hvp_w34101n_l2000n_ng4 PSP103VA TYPE=-1 TR=27 DTA=0 SWGEO=1 SWIGATE=1 SWIMPACT=1 SWGIDL=1 SWJUNCAP=3 SWJUNASYM=0 SWNUD=0 SWEDGE=0 SWDELVTAC=0 SWIGN=1 QMC=1 LVARO=-1.735e-09 LVARL=0 LVARW=0 LAP=3.471e-08 WVARO=0 WVARL=0 WVARW=0 WOT=0 DLQ=3.537e-08 DWQ=3e-08 VFBO=-1.0717 VFBL=-0.03 VFBW=0 VFBLW=0 STVFBO=0.00057379 STVFBL=8.6794e-05 STVFBW=4.9309e-05 STVFBLW=-3.6436e-05 ST2VFBO=0 TOXO=6.945e-09 EPSROXO=3.9 NSUBO=4.2268e+23 NSUBW=0.01112 WSEG=5.362e-08 NPCK=8.0711e+23 NPCKW=-0.011403 WSEGP=1e-06 LPCK=8.3733e-09 LPCKW=0.077499 FOL1=0.065253 FOL2=0.010199 FACNEFFACO=1 FACNEFFACL=0 FACNEFFACW=0 FACNEFFACLW=0 GFACNUDO=1 GFACNUDL=0 GFACNUDLEXP=1 GFACNUDW=0 GFACNUDLW=0 VSBNUDO=0 DVSBNUDO=1 VNSUBO=0 NSLPO=0.05 DNSUBO=0.03585 DPHIBO=-0.077884807 DPHIBL=0.00526388544 DPHIBLEXP=2.1893 DPHIBW=-0.011141504 DPHIBLW=-9.3915789e-05 DELVTACO=0 DELVTACL=0 DELVTACLEXP=1 DELVTACW=0 DELVTACLW=0 NPO=1.092e+26 NPL=0.2188 TOXOVO=6.945e-09 TOXOVDO=2e-09 LOV=3.471e-08 LOVD=0 NOVO=1.99e+26 NOVDO=5e+25 CTO=-0.006328 CTL=0 CTLEXP=1 CTW=0.3006 CTLW=-0.01196 CTGO=0 CTBO=0 STCTO=1 CFL=0.00045884 CFLEXP=2.2055 CFW=0.45909 CFBO=1 CFDO=0 PSCEL=0 PSCELEXP=2 PSCEW=0 PSCEBO=0 PSCEDO=0 UO=0.018428 FBET1=0.15952 FBET1W=-2.1872 LP1=9.9822e-08 LP1W=-1.0871 FBET2=-2.7066 LP2=5.8401e-08 BETW1=-0.097534 BETW2=0.022314 WBET=7.9844e-10 STBETO=1.6489 STBETL=0.029528 STBETW=0.037078 STBETLW=0.046991 MUEO=1.7444601 MUEW=-0.06367 STMUEO=1.0816 THEMUO=1.0324 STTHEMUO=0.26337 CSO=0.18648 CSL=0.21903 CSLEXP=2.0917 CSW=0.0072837 CSLW=0.02 STCSO=2 THECSO=2 STTHECSO=0 XCORO=0.001363 XCORL=8 XCORW=0.0060537 XCORLW=0.058951 STXCORO=-6.939e-18 FETAO=1.2853 RSW1=1970 RSW2=-0.057547 STRSO=-0.24812 RSBO=0.074639 RSGO=0.23490984 THESATO=8.4917e-05 THESATL=0.0067396 THESATLEXP=2.395 THESATW=1.1549 THESATLW=-0.01 STTHESATO=3.0405 STTHESATL=-0.16001 STTHESATW=-0.96988 STTHESATLW=0.36213 THESATBO=0.1 THESATGO=0.6304 AXO=16.822 AXL=3.0092 ALPL=0.0058454 ALPLEXP=0.47562 ALPW=-0.065973 ALP1L1=4.4409e-16 ALP1LEXP=1.347 ALP1L2=1 ALP1W=2 ALP2L1=3.6779e-06 ALP2LEXP=0.2531 ALP2L2=2.2204e-15 ALP2W=0.9582 VPO=1.8436e-06 A1O=47.788 A1L=0.029145 A1W=0.01435 A2O=38.581 STA2O=-0.0049931 A3O=1.1753 A3L=-0.069795 A3W=0.0032538 A4O=0.12593 A4L=-0.07 A4W=-0.04811 GCOO=0 IGINVLW=0 IGOVW=0 IGOVDW=0 STIGO=2 GC2O=0.375 GC3O=0.063 CHIBO=3.1 AGIDLW=6e-10 AGIDLDW=0 BGIDLO=5.5970304 BGIDLDO=41 STBGIDLO=-0.0049461 STBGIDLDO=0 CGIDLO=0.23693 CGIDLDO=0 CGBOVL=-4.669e-16 CFRDW=0 FNTO=1 FNTEXCL=0 NFALW=1.3e+25 NFBLW=5289000000 NFCLW=2e-07 EFO=1.152 LINTNOI=2.5e-08 ALPNOI=2 WEDGE=1e-08 WEDGEW=0 VFBEDGEO=-1 STVFBEDGEO=0.0005 STVFBEDGEL=0 STVFBEDGEW=0 STVFBEDGELW=0 DPHIBEDGEO=0 DPHIBEDGEL=0 DPHIBEDGELEXP=1 DPHIBEDGEW=0 DPHIBEDGELW=0 NSUBEDGEO=5e+23 NSUBEDGEL=0 NSUBEDGELEXP=1 NSUBEDGEW=0 NSUBEDGELW=0 CTEDGEO=0 CTEDGEL=0 CTEDGELEXP=1 FBETEDGE=0 LPEDGE=1e-08 BETEDGEW=0 STBETEDGEO=1 STBETEDGEL=0 STBETEDGEW=0 STBETEDGELW=0 PSCEEDGEL=0 PSCEEDGELEXP=2 PSCEEDGEW=0 PSCEBEDGEO=0 PSCEDEDGEO=0 CFEDGEL=0 CFEDGELEXP=2 CFEDGEW=0 CFDEDGEO=0 CFBEDGEO=0 FNTEDGEO=1 NFAEDGELW=8e+22 NFBEDGELW=30000000 NFCEDGELW=0 EFEDGEO=1 SAREF=1e-06 SBREF=1e-06 WLOD=0 KUO=0 KVSAT=0 TKUO=0 LKUO=0 WKUO=0 PKUO=0 LLODKUO=0 WLODKUO=0 KVTHO=0 LKVTHO=0 WKVTHO=0 PKVTHO=0 LLODVTH=0 WLODVTH=0 STETAO=0 LODETAO=1 SCREF=1e-06 WEB=0 WEC=0 KVTHOWEO=0 KVTHOWEL=0 KVTHOWEW=0 KVTHOWELW=0 KUOWEO=0 KUOWEL=0 KUOWEW=0 KUOWELW=0 TRJ=21 SWJUNEXP=0 IMAX=0.0024527 FREV=1000 CJORBOT=0.0008095 CJORSTI=4.2583e-11 CJORGAT=3.1e-11 VBIRBOT=0.72606 VBIRSTI=0.69819 VBIRGAT=1.199 PBOT=0.33078 PSTI=0.22409 PGAT=0.4474 CJORBOTD=0.001 CJORSTID=1e-09 CJORGATD=1e-09 VBIRBOTD=1 VBIRSTID=1 VBIRGATD=1 PBOTD=0.5 PSTID=0.5 PGATD=0.5 PHIGBOT=1.0641 PHIGSTI=1.3946 PHIGGAT=1.83 IDSATRBOT=3.0606e-08 IDSATRSTI=3.6127e-15 IDSATRGAT=0 CSRHBOT=100 CSRHSTI=0.0001 CSRHGAT=0.0001 XJUNSTI=4.93e-08 XJUNGAT=7.062e-07 PHIGBOTD=1.16 PHIGSTID=1.16 PHIGGATD=1.16 IDSATRBOTD=1e-12 IDSATRSTID=1e-18 IDSATRGATD=1e-18 CSRHBOTD=100 CSRHSTID=0.0001 CSRHGATD=0.0001 XJUNSTID=1e-07 XJUNGATD=1e-07 CTATBOT=100 CTATSTI=0.0001 CTATGAT=0.0001 MEFFTATBOT=0.25 MEFFTATSTI=0.25 MEFFTATGAT=0.25 CTATBOTD=100 CTATSTID=0.0001 CTATGATD=0.0001 MEFFTATBOTD=0.25 MEFFTATSTID=0.25 MEFFTATGATD=0.25 CBBTBOT=1e-12 CBBTSTI=1e-21 CBBTGAT=1e-18 FBBTRBOT=1000000000 FBBTRSTI=1000000000 FBBTRGAT=1000000000 STFBBTBOT=-0.001 STFBBTSTI=-0.001 STFBBTGAT=-0.001 CBBTBOTD=1e-12 CBBTSTID=1e-18 CBBTGATD=1e-18 FBBTRBOTD=1000000000 FBBTRSTID=1000000000 FBBTRGATD=1000000000 STFBBTBOTD=-0.001 STFBBTSTID=-0.001 STFBBTGATD=-0.001 VBRBOT=10 VBRSTI=10 VBRGAT=10 PBRBOT=4 PBRSTI=4 PBRGAT=4 VBRBOTD=10 VBRSTID=10 VBRGATD=10 PBRBOTD=4 PBRSTID=4 PBRGATD=4 VJUNREF=2.5 FJUNQ=0.03 VJUNREFD=2.5 FJUNQD=0.03 RINT=0 RVPOLY=0 DLSIL=0 RSH=0 RSHD=0 CFRW=0 RSHG=40 RGO=15 RBULKO=234.5984 RWELLO=117.2992 RJUNSO=293.248 RJUNDO=293.248 SWSOA=0 VGS_MAX=3 VGD_MAX=3 VGB_MAX=3 VDS_MAX=3 VDB_MAX=1.6 VSB_MAX=1.6
model hvp_w34101n_l400n_ng4 PSP103VA TYPE=-1 TR=27 DTA=0 SWGEO=1 SWIGATE=1 SWIMPACT=1 SWGIDL=1 SWJUNCAP=3 SWJUNASYM=0 SWNUD=0 SWEDGE=0 SWDELVTAC=0 SWIGN=1 QMC=1 LVARO=-1.735e-09 LVARL=0 LVARW=0 LAP=3.471e-08 WVARO=0 WVARL=0 WVARW=0 WOT=0 DLQ=3.537e-08 DWQ=3e-08 VFBO=-1.0717 VFBL=-0.03 VFBW=0 VFBLW=0 STVFBO=0.00057379 STVFBL=8.6794e-05 STVFBW=4.9309e-05 STVFBLW=-3.6436e-05 ST2VFBO=0 TOXO=6.945e-09 EPSROXO=3.9 NSUBO=4.2268e+23 NSUBW=0.01112 WSEG=5.362e-08 NPCK=8.0711e+23 NPCKW=-0.011403 WSEGP=1e-06 LPCK=8.3733e-09 LPCKW=0.077499 FOL1=0.065253 FOL2=0.010199 FACNEFFACO=1 FACNEFFACL=0 FACNEFFACW=0 FACNEFFACLW=0 GFACNUDO=1 GFACNUDL=0 GFACNUDLEXP=1 GFACNUDW=0 GFACNUDLW=0 VSBNUDO=0 DVSBNUDO=1 VNSUBO=0 NSLPO=0.05 DNSUBO=0.03585 DPHIBO=-0.077884807 DPHIBL=0.00526388544 DPHIBLEXP=2.1893 DPHIBW=-0.011141504 DPHIBLW=-9.3915789e-05 DELVTACO=0 DELVTACL=0 DELVTACLEXP=1 DELVTACW=0 DELVTACLW=0 NPO=1.092e+26 NPL=0.2188 TOXOVO=6.945e-09 TOXOVDO=2e-09 LOV=3.471e-08 LOVD=0 NOVO=1.99e+26 NOVDO=5e+25 CTO=-0.006328 CTL=0 CTLEXP=1 CTW=0.3006 CTLW=-0.01196 CTGO=0 CTBO=0 STCTO=1 CFL=0.00045884 CFLEXP=2.2055 CFW=0.45909 CFBO=1 CFDO=0 PSCEL=0 PSCELEXP=2 PSCEW=0 PSCEBO=0 PSCEDO=0 UO=0.018428 FBET1=0.15952 FBET1W=-2.1872 LP1=9.9822e-08 LP1W=-1.0871 FBET2=-2.7066 LP2=5.8401e-08 BETW1=-0.097534 BETW2=0.022314 WBET=7.9844e-10 STBETO=1.6489 STBETL=0.029528 STBETW=0.037078 STBETLW=0.046991 MUEO=1.7444601 MUEW=-0.06367 STMUEO=1.0816 THEMUO=1.0324 STTHEMUO=0.26337 CSO=0.18648 CSL=0.21903 CSLEXP=2.0917 CSW=0.0072837 CSLW=0.02 STCSO=2 THECSO=2 STTHECSO=0 XCORO=0.001363 XCORL=8 XCORW=0.0060537 XCORLW=0.058951 STXCORO=-6.939e-18 FETAO=1.2853 RSW1=1970 RSW2=-0.057547 STRSO=-0.24812 RSBO=0.074639 RSGO=0.23490984 THESATO=8.4917e-05 THESATL=0.0067396 THESATLEXP=2.395 THESATW=1.1549 THESATLW=-0.01 STTHESATO=3.0405 STTHESATL=-0.16001 STTHESATW=-0.96988 STTHESATLW=0.36213 THESATBO=0.1 THESATGO=0.6304 AXO=16.822 AXL=3.0092 ALPL=0.0058454 ALPLEXP=0.47562 ALPW=-0.065973 ALP1L1=4.4409e-16 ALP1LEXP=1.347 ALP1L2=1 ALP1W=2 ALP2L1=3.6779e-06 ALP2LEXP=0.2531 ALP2L2=2.2204e-15 ALP2W=0.9582 VPO=1.8436e-06 A1O=47.788 A1L=0.029145 A1W=0.01435 A2O=38.581 STA2O=-0.0049931 A3O=1.1753 A3L=-0.069795 A3W=0.0032538 A4O=0.12593 A4L=-0.07 A4W=-0.04811 GCOO=0 IGINVLW=0 IGOVW=0 IGOVDW=0 STIGO=2 GC2O=0.375 GC3O=0.063 CHIBO=3.1 AGIDLW=6e-10 AGIDLDW=0 BGIDLO=5.5970304 BGIDLDO=41 STBGIDLO=-0.0049461 STBGIDLDO=0 CGIDLO=0.23693 CGIDLDO=0 CGBOVL=-4.669e-16 CFRDW=0 FNTO=1 FNTEXCL=0 NFALW=1.3e+25 NFBLW=5289000000 NFCLW=2e-07 EFO=1.152 LINTNOI=2.5e-08 ALPNOI=2 WEDGE=1e-08 WEDGEW=0 VFBEDGEO=-1 STVFBEDGEO=0.0005 STVFBEDGEL=0 STVFBEDGEW=0 STVFBEDGELW=0 DPHIBEDGEO=0 DPHIBEDGEL=0 DPHIBEDGELEXP=1 DPHIBEDGEW=0 DPHIBEDGELW=0 NSUBEDGEO=5e+23 NSUBEDGEL=0 NSUBEDGELEXP=1 NSUBEDGEW=0 NSUBEDGELW=0 CTEDGEO=0 CTEDGEL=0 CTEDGELEXP=1 FBETEDGE=0 LPEDGE=1e-08 BETEDGEW=0 STBETEDGEO=1 STBETEDGEL=0 STBETEDGEW=0 STBETEDGELW=0 PSCEEDGEL=0 PSCEEDGELEXP=2 PSCEEDGEW=0 PSCEBEDGEO=0 PSCEDEDGEO=0 CFEDGEL=0 CFEDGELEXP=2 CFEDGEW=0 CFDEDGEO=0 CFBEDGEO=0 FNTEDGEO=1 NFAEDGELW=8e+22 NFBEDGELW=30000000 NFCEDGELW=0 EFEDGEO=1 SAREF=1e-06 SBREF=1e-06 WLOD=0 KUO=0 KVSAT=0 TKUO=0 LKUO=0 WKUO=0 PKUO=0 LLODKUO=0 WLODKUO=0 KVTHO=0 LKVTHO=0 WKVTHO=0 PKVTHO=0 LLODVTH=0 WLODVTH=0 STETAO=0 LODETAO=1 SCREF=1e-06 WEB=0 WEC=0 KVTHOWEO=0 KVTHOWEL=0 KVTHOWEW=0 KVTHOWELW=0 KUOWEO=0 KUOWEL=0 KUOWEW=0 KUOWELW=0 TRJ=21 SWJUNEXP=0 IMAX=0.0024527 FREV=1000 CJORBOT=0.0008095 CJORSTI=4.2583e-11 CJORGAT=3.1e-11 VBIRBOT=0.72606 VBIRSTI=0.69819 VBIRGAT=1.199 PBOT=0.33078 PSTI=0.22409 PGAT=0.4474 CJORBOTD=0.001 CJORSTID=1e-09 CJORGATD=1e-09 VBIRBOTD=1 VBIRSTID=1 VBIRGATD=1 PBOTD=0.5 PSTID=0.5 PGATD=0.5 PHIGBOT=1.0641 PHIGSTI=1.3946 PHIGGAT=1.83 IDSATRBOT=3.0606e-08 IDSATRSTI=3.6127e-15 IDSATRGAT=0 CSRHBOT=100 CSRHSTI=0.0001 CSRHGAT=0.0001 XJUNSTI=4.93e-08 XJUNGAT=7.062e-07 PHIGBOTD=1.16 PHIGSTID=1.16 PHIGGATD=1.16 IDSATRBOTD=1e-12 IDSATRSTID=1e-18 IDSATRGATD=1e-18 CSRHBOTD=100 CSRHSTID=0.0001 CSRHGATD=0.0001 XJUNSTID=1e-07 XJUNGATD=1e-07 CTATBOT=100 CTATSTI=0.0001 CTATGAT=0.0001 MEFFTATBOT=0.25 MEFFTATSTI=0.25 MEFFTATGAT=0.25 CTATBOTD=100 CTATSTID=0.0001 CTATGATD=0.0001 MEFFTATBOTD=0.25 MEFFTATSTID=0.25 MEFFTATGATD=0.25 CBBTBOT=1e-12 CBBTSTI=1e-21 CBBTGAT=1e-18 FBBTRBOT=1000000000 FBBTRSTI=1000000000 FBBTRGAT=1000000000 STFBBTBOT=-0.001 STFBBTSTI=-0.001 STFBBTGAT=-0.001 CBBTBOTD=1e-12 CBBTSTID=1e-18 CBBTGATD=1e-18 FBBTRBOTD=1000000000 FBBTRSTID=1000000000 FBBTRGATD=1000000000 STFBBTBOTD=-0.001 STFBBTSTID=-0.001 STFBBTGATD=-0.001 VBRBOT=10 VBRSTI=10 VBRGAT=10 PBRBOT=4 PBRSTI=4 PBRGAT=4 VBRBOTD=10 VBRSTID=10 VBRGATD=10 PBRBOTD=4 PBRSTID=4 PBRGATD=4 VJUNREF=2.5 FJUNQ=0.03 VJUNREFD=2.5 FJUNQD=0.03 RINT=0 RVPOLY=0 DLSIL=0 RSH=0 RSHD=0 CFRW=0 RSHG=40 RGO=15 RBULKO=234.5984 RWELLO=117.2992 RJUNSO=58.6496 RJUNDO=58.6496 SWSOA=0 VGS_MAX=3 VGD_MAX=3 VGB_MAX=3 VDS_MAX=3 VDB_MAX=1.6 VSB_MAX=1.6
model hvp_w34527n_l2000n_ng4 PSP103VA TYPE=-1 TR=27 DTA=0 SWGEO=1 SWIGATE=1 SWIMPACT=1 SWGIDL=1 SWJUNCAP=3 SWJUNASYM=0 SWNUD=0 SWEDGE=0 SWDELVTAC=0 SWIGN=1 QMC=1 LVARO=-1.735e-09 LVARL=0 LVARW=0 LAP=3.471e-08 WVARO=0 WVARL=0 WVARW=0 WOT=0 DLQ=3.537e-08 DWQ=3e-08 VFBO=-1.0717 VFBL=-0.03 VFBW=0 VFBLW=0 STVFBO=0.00057379 STVFBL=8.6794e-05 STVFBW=4.9309e-05 STVFBLW=-3.6436e-05 ST2VFBO=0 TOXO=6.945e-09 EPSROXO=3.9 NSUBO=4.2268e+23 NSUBW=0.01112 WSEG=5.362e-08 NPCK=8.0711e+23 NPCKW=-0.011403 WSEGP=1e-06 LPCK=8.3733e-09 LPCKW=0.077499 FOL1=0.065253 FOL2=0.010199 FACNEFFACO=1 FACNEFFACL=0 FACNEFFACW=0 FACNEFFACLW=0 GFACNUDO=1 GFACNUDL=0 GFACNUDLEXP=1 GFACNUDW=0 GFACNUDLW=0 VSBNUDO=0 DVSBNUDO=1 VNSUBO=0 NSLPO=0.05 DNSUBO=0.03585 DPHIBO=-0.077884807 DPHIBL=0.00526388544 DPHIBLEXP=2.1893 DPHIBW=-0.011141504 DPHIBLW=-9.3915789e-05 DELVTACO=0 DELVTACL=0 DELVTACLEXP=1 DELVTACW=0 DELVTACLW=0 NPO=1.092e+26 NPL=0.2188 TOXOVO=6.945e-09 TOXOVDO=2e-09 LOV=3.471e-08 LOVD=0 NOVO=1.99e+26 NOVDO=5e+25 CTO=-0.006328 CTL=0 CTLEXP=1 CTW=0.3006 CTLW=-0.01196 CTGO=0 CTBO=0 STCTO=1 CFL=0.00045884 CFLEXP=2.2055 CFW=0.45909 CFBO=1 CFDO=0 PSCEL=0 PSCELEXP=2 PSCEW=0 PSCEBO=0 PSCEDO=0 UO=0.018428 FBET1=0.15952 FBET1W=-2.1872 LP1=9.9822e-08 LP1W=-1.0871 FBET2=-2.7066 LP2=5.8401e-08 BETW1=-0.097534 BETW2=0.022314 WBET=7.9844e-10 STBETO=1.6489 STBETL=0.029528 STBETW=0.037078 STBETLW=0.046991 MUEO=1.7444601 MUEW=-0.06367 STMUEO=1.0816 THEMUO=1.0324 STTHEMUO=0.26337 CSO=0.18648 CSL=0.21903 CSLEXP=2.0917 CSW=0.0072837 CSLW=0.02 STCSO=2 THECSO=2 STTHECSO=0 XCORO=0.001363 XCORL=8 XCORW=0.0060537 XCORLW=0.058951 STXCORO=-6.939e-18 FETAO=1.2853 RSW1=1970 RSW2=-0.057547 STRSO=-0.24812 RSBO=0.074639 RSGO=0.23490984 THESATO=8.4917e-05 THESATL=0.0067396 THESATLEXP=2.395 THESATW=1.1549 THESATLW=-0.01 STTHESATO=3.0405 STTHESATL=-0.16001 STTHESATW=-0.96988 STTHESATLW=0.36213 THESATBO=0.1 THESATGO=0.6304 AXO=16.822 AXL=3.0092 ALPL=0.0058454 ALPLEXP=0.47562 ALPW=-0.065973 ALP1L1=4.4409e-16 ALP1LEXP=1.347 ALP1L2=1 ALP1W=2 ALP2L1=3.6779e-06 ALP2LEXP=0.2531 ALP2L2=2.2204e-15 ALP2W=0.9582 VPO=1.8436e-06 A1O=47.788 A1L=0.029145 A1W=0.01435 A2O=38.581 STA2O=-0.0049931 A3O=1.1753 A3L=-0.069795 A3W=0.0032538 A4O=0.12593 A4L=-0.07 A4W=-0.04811 GCOO=0 IGINVLW=0 IGOVW=0 IGOVDW=0 STIGO=2 GC2O=0.375 GC3O=0.063 CHIBO=3.1 AGIDLW=6e-10 AGIDLDW=0 BGIDLO=5.5970304 BGIDLDO=41 STBGIDLO=-0.0049461 STBGIDLDO=0 CGIDLO=0.23693 CGIDLDO=0 CGBOVL=-4.669e-16 CFRDW=0 FNTO=1 FNTEXCL=0 NFALW=1.3e+25 NFBLW=5289000000 NFCLW=2e-07 EFO=1.152 LINTNOI=2.5e-08 ALPNOI=2 WEDGE=1e-08 WEDGEW=0 VFBEDGEO=-1 STVFBEDGEO=0.0005 STVFBEDGEL=0 STVFBEDGEW=0 STVFBEDGELW=0 DPHIBEDGEO=0 DPHIBEDGEL=0 DPHIBEDGELEXP=1 DPHIBEDGEW=0 DPHIBEDGELW=0 NSUBEDGEO=5e+23 NSUBEDGEL=0 NSUBEDGELEXP=1 NSUBEDGEW=0 NSUBEDGELW=0 CTEDGEO=0 CTEDGEL=0 CTEDGELEXP=1 FBETEDGE=0 LPEDGE=1e-08 BETEDGEW=0 STBETEDGEO=1 STBETEDGEL=0 STBETEDGEW=0 STBETEDGELW=0 PSCEEDGEL=0 PSCEEDGELEXP=2 PSCEEDGEW=0 PSCEBEDGEO=0 PSCEDEDGEO=0 CFEDGEL=0 CFEDGELEXP=2 CFEDGEW=0 CFDEDGEO=0 CFBEDGEO=0 FNTEDGEO=1 NFAEDGELW=8e+22 NFBEDGELW=30000000 NFCEDGELW=0 EFEDGEO=1 SAREF=1e-06 SBREF=1e-06 WLOD=0 KUO=0 KVSAT=0 TKUO=0 LKUO=0 WKUO=0 PKUO=0 LLODKUO=0 WLODKUO=0 KVTHO=0 LKVTHO=0 WKVTHO=0 PKVTHO=0 LLODVTH=0 WLODVTH=0 STETAO=0 LODETAO=1 SCREF=1e-06 WEB=0 WEC=0 KVTHOWEO=0 KVTHOWEL=0 KVTHOWEW=0 KVTHOWELW=0 KUOWEO=0 KUOWEL=0 KUOWEW=0 KUOWELW=0 TRJ=21 SWJUNEXP=0 IMAX=0.0024527 FREV=1000 CJORBOT=0.0008095 CJORSTI=4.2583e-11 CJORGAT=3.1e-11 VBIRBOT=0.72606 VBIRSTI=0.69819 VBIRGAT=1.199 PBOT=0.33078 PSTI=0.22409 PGAT=0.4474 CJORBOTD=0.001 CJORSTID=1e-09 CJORGATD=1e-09 VBIRBOTD=1 VBIRSTID=1 VBIRGATD=1 PBOTD=0.5 PSTID=0.5 PGATD=0.5 PHIGBOT=1.0641 PHIGSTI=1.3946 PHIGGAT=1.83 IDSATRBOT=3.0606e-08 IDSATRSTI=3.6127e-15 IDSATRGAT=0 CSRHBOT=100 CSRHSTI=0.0001 CSRHGAT=0.0001 XJUNSTI=4.93e-08 XJUNGAT=7.062e-07 PHIGBOTD=1.16 PHIGSTID=1.16 PHIGGATD=1.16 IDSATRBOTD=1e-12 IDSATRSTID=1e-18 IDSATRGATD=1e-18 CSRHBOTD=100 CSRHSTID=0.0001 CSRHGATD=0.0001 XJUNSTID=1e-07 XJUNGATD=1e-07 CTATBOT=100 CTATSTI=0.0001 CTATGAT=0.0001 MEFFTATBOT=0.25 MEFFTATSTI=0.25 MEFFTATGAT=0.25 CTATBOTD=100 CTATSTID=0.0001 CTATGATD=0.0001 MEFFTATBOTD=0.25 MEFFTATSTID=0.25 MEFFTATGATD=0.25 CBBTBOT=1e-12 CBBTSTI=1e-21 CBBTGAT=1e-18 FBBTRBOT=1000000000 FBBTRSTI=1000000000 FBBTRGAT=1000000000 STFBBTBOT=-0.001 STFBBTSTI=-0.001 STFBBTGAT=-0.001 CBBTBOTD=1e-12 CBBTSTID=1e-18 CBBTGATD=1e-18 FBBTRBOTD=1000000000 FBBTRSTID=1000000000 FBBTRGATD=1000000000 STFBBTBOTD=-0.001 STFBBTSTID=-0.001 STFBBTGATD=-0.001 VBRBOT=10 VBRSTI=10 VBRGAT=10 PBRBOT=4 PBRSTI=4 PBRGAT=4 VBRBOTD=10 VBRSTID=10 VBRGATD=10 PBRBOTD=4 PBRSTID=4 PBRGATD=4 VJUNREF=2.5 FJUNQ=0.03 VJUNREFD=2.5 FJUNQD=0.03 RINT=0 RVPOLY=0 DLSIL=0 RSH=0 RSHD=0 CFRW=0 RSHG=40 RGO=15 RBULKO=231.7021235 RWELLO=115.8510617 RJUNSO=289.6276543 RJUNDO=289.6276543 SWSOA=0 VGS_MAX=3 VGD_MAX=3 VGB_MAX=3 VDS_MAX=3 VDB_MAX=1.6 VSB_MAX=1.6
model hvp_w4000n_l1000n_ng1 PSP103VA TYPE=-1 TR=27 DTA=0 SWGEO=1 SWIGATE=1 SWIMPACT=1 SWGIDL=1 SWJUNCAP=3 SWJUNASYM=0 SWNUD=0 SWEDGE=0 SWDELVTAC=0 SWIGN=1 QMC=1 LVARO=-1.735e-09 LVARL=0 LVARW=0 LAP=3.471e-08 WVARO=0 WVARL=0 WVARW=0 WOT=0 DLQ=3.537e-08 DWQ=3e-08 VFBO=-1.0717 VFBL=-0.03 VFBW=0 VFBLW=0 STVFBO=0.00057379 STVFBL=8.6794e-05 STVFBW=4.9309e-05 STVFBLW=-3.6436e-05 ST2VFBO=0 TOXO=6.945e-09 EPSROXO=3.9 NSUBO=4.2268e+23 NSUBW=0.01112 WSEG=5.362e-08 NPCK=8.0711e+23 NPCKW=-0.011403 WSEGP=1e-06 LPCK=8.3733e-09 LPCKW=0.077499 FOL1=0.065253 FOL2=0.010199 FACNEFFACO=1 FACNEFFACL=0 FACNEFFACW=0 FACNEFFACLW=0 GFACNUDO=1 GFACNUDL=0 GFACNUDLEXP=1 GFACNUDW=0 GFACNUDLW=0 VSBNUDO=0 DVSBNUDO=1 VNSUBO=0 NSLPO=0.05 DNSUBO=0.03585 DPHIBO=-0.077884807 DPHIBL=0.00526388544 DPHIBLEXP=2.1893 DPHIBW=-0.011141504 DPHIBLW=-9.3915789e-05 DELVTACO=0 DELVTACL=0 DELVTACLEXP=1 DELVTACW=0 DELVTACLW=0 NPO=1.092e+26 NPL=0.2188 TOXOVO=6.945e-09 TOXOVDO=2e-09 LOV=3.471e-08 LOVD=0 NOVO=1.99e+26 NOVDO=5e+25 CTO=-0.006328 CTL=0 CTLEXP=1 CTW=0.3006 CTLW=-0.01196 CTGO=0 CTBO=0 STCTO=1 CFL=0.00045884 CFLEXP=2.2055 CFW=0.45909 CFBO=1 CFDO=0 PSCEL=0 PSCELEXP=2 PSCEW=0 PSCEBO=0 PSCEDO=0 UO=0.018428 FBET1=0.15952 FBET1W=-2.1872 LP1=9.9822e-08 LP1W=-1.0871 FBET2=-2.7066 LP2=5.8401e-08 BETW1=-0.097534 BETW2=0.022314 WBET=7.9844e-10 STBETO=1.6489 STBETL=0.029528 STBETW=0.037078 STBETLW=0.046991 MUEO=1.7444601 MUEW=-0.06367 STMUEO=1.0816 THEMUO=1.0324 STTHEMUO=0.26337 CSO=0.18648 CSL=0.21903 CSLEXP=2.0917 CSW=0.0072837 CSLW=0.02 STCSO=2 THECSO=2 STTHECSO=0 XCORO=0.001363 XCORL=8 XCORW=0.0060537 XCORLW=0.058951 STXCORO=-6.939e-18 FETAO=1.2853 RSW1=1970 RSW2=-0.057547 STRSO=-0.24812 RSBO=0.074639 RSGO=0.23490984 THESATO=8.4917e-05 THESATL=0.0067396 THESATLEXP=2.395 THESATW=1.1549 THESATLW=-0.01 STTHESATO=3.0405 STTHESATL=-0.16001 STTHESATW=-0.96988 STTHESATLW=0.36213 THESATBO=0.1 THESATGO=0.6304 AXO=16.822 AXL=3.0092 ALPL=0.0058454 ALPLEXP=0.47562 ALPW=-0.065973 ALP1L1=4.4409e-16 ALP1LEXP=1.347 ALP1L2=1 ALP1W=2 ALP2L1=3.6779e-06 ALP2LEXP=0.2531 ALP2L2=2.2204e-15 ALP2W=0.9582 VPO=1.8436e-06 A1O=47.788 A1L=0.029145 A1W=0.01435 A2O=38.581 STA2O=-0.0049931 A3O=1.1753 A3L=-0.069795 A3W=0.0032538 A4O=0.12593 A4L=-0.07 A4W=-0.04811 GCOO=0 IGINVLW=0 IGOVW=0 IGOVDW=0 STIGO=2 GC2O=0.375 GC3O=0.063 CHIBO=3.1 AGIDLW=6e-10 AGIDLDW=0 BGIDLO=5.5970304 BGIDLDO=41 STBGIDLO=-0.0049461 STBGIDLDO=0 CGIDLO=0.23693 CGIDLDO=0 CGBOVL=-4.669e-16 CFRDW=0 FNTO=1 FNTEXCL=0 NFALW=1.3e+25 NFBLW=5289000000 NFCLW=2e-07 EFO=1.152 LINTNOI=2.5e-08 ALPNOI=2 WEDGE=1e-08 WEDGEW=0 VFBEDGEO=-1 STVFBEDGEO=0.0005 STVFBEDGEL=0 STVFBEDGEW=0 STVFBEDGELW=0 DPHIBEDGEO=0 DPHIBEDGEL=0 DPHIBEDGELEXP=1 DPHIBEDGEW=0 DPHIBEDGELW=0 NSUBEDGEO=5e+23 NSUBEDGEL=0 NSUBEDGELEXP=1 NSUBEDGEW=0 NSUBEDGELW=0 CTEDGEO=0 CTEDGEL=0 CTEDGELEXP=1 FBETEDGE=0 LPEDGE=1e-08 BETEDGEW=0 STBETEDGEO=1 STBETEDGEL=0 STBETEDGEW=0 STBETEDGELW=0 PSCEEDGEL=0 PSCEEDGELEXP=2 PSCEEDGEW=0 PSCEBEDGEO=0 PSCEDEDGEO=0 CFEDGEL=0 CFEDGELEXP=2 CFEDGEW=0 CFDEDGEO=0 CFBEDGEO=0 FNTEDGEO=1 NFAEDGELW=8e+22 NFBEDGELW=30000000 NFCEDGELW=0 EFEDGEO=1 SAREF=1e-06 SBREF=1e-06 WLOD=0 KUO=0 KVSAT=0 TKUO=0 LKUO=0 WKUO=0 PKUO=0 LLODKUO=0 WLODKUO=0 KVTHO=0 LKVTHO=0 WKVTHO=0 PKVTHO=0 LLODVTH=0 WLODVTH=0 STETAO=0 LODETAO=1 SCREF=1e-06 WEB=0 WEC=0 KVTHOWEO=0 KVTHOWEL=0 KVTHOWEW=0 KVTHOWELW=0 KUOWEO=0 KUOWEL=0 KUOWEW=0 KUOWELW=0 TRJ=21 SWJUNEXP=0 IMAX=0.0024527 FREV=1000 CJORBOT=0.0008095 CJORSTI=4.2583e-11 CJORGAT=3.1e-11 VBIRBOT=0.72606 VBIRSTI=0.69819 VBIRGAT=1.199 PBOT=0.33078 PSTI=0.22409 PGAT=0.4474 CJORBOTD=0.001 CJORSTID=1e-09 CJORGATD=1e-09 VBIRBOTD=1 VBIRSTID=1 VBIRGATD=1 PBOTD=0.5 PSTID=0.5 PGATD=0.5 PHIGBOT=1.0641 PHIGSTI=1.3946 PHIGGAT=1.83 IDSATRBOT=3.0606e-08 IDSATRSTI=3.6127e-15 IDSATRGAT=0 CSRHBOT=100 CSRHSTI=0.0001 CSRHGAT=0.0001 XJUNSTI=4.93e-08 XJUNGAT=7.062e-07 PHIGBOTD=1.16 PHIGSTID=1.16 PHIGGATD=1.16 IDSATRBOTD=1e-12 IDSATRSTID=1e-18 IDSATRGATD=1e-18 CSRHBOTD=100 CSRHSTID=0.0001 CSRHGATD=0.0001 XJUNSTID=1e-07 XJUNGATD=1e-07 CTATBOT=100 CTATSTI=0.0001 CTATGAT=0.0001 MEFFTATBOT=0.25 MEFFTATSTI=0.25 MEFFTATGAT=0.25 CTATBOTD=100 CTATSTID=0.0001 CTATGATD=0.0001 MEFFTATBOTD=0.25 MEFFTATSTID=0.25 MEFFTATGATD=0.25 CBBTBOT=1e-12 CBBTSTI=1e-21 CBBTGAT=1e-18 FBBTRBOT=1000000000 FBBTRSTI=1000000000 FBBTRGAT=1000000000 STFBBTBOT=-0.001 STFBBTSTI=-0.001 STFBBTGAT=-0.001 CBBTBOTD=1e-12 CBBTSTID=1e-18 CBBTGATD=1e-18 FBBTRBOTD=1000000000 FBBTRSTID=1000000000 FBBTRGATD=1000000000 STFBBTBOTD=-0.001 STFBBTSTID=-0.001 STFBBTGATD=-0.001 VBRBOT=10 VBRSTI=10 VBRGAT=10 PBRBOT=4 PBRSTI=4 PBRGAT=4 VBRBOTD=10 VBRSTID=10 VBRGATD=10 PBRBOTD=4 PBRSTID=4 PBRGATD=4 VJUNREF=2.5 FJUNQ=0.03 VJUNREFD=2.5 FJUNQD=0.03 RINT=0 RVPOLY=0 DLSIL=0 RSH=0 RSHD=0 CFRW=0 RSHG=40 RGO=15 RBULKO=500 RWELLO=250 RJUNSO=1250 RJUNDO=1250 SWSOA=0 VGS_MAX=3 VGD_MAX=3 VGB_MAX=3 VDS_MAX=3 VDB_MAX=1.6 VSB_MAX=1.6
model hvp_w4000n_l2000n_ng1 PSP103VA TYPE=-1 TR=27 DTA=0 SWGEO=1 SWIGATE=1 SWIMPACT=1 SWGIDL=1 SWJUNCAP=3 SWJUNASYM=0 SWNUD=0 SWEDGE=0 SWDELVTAC=0 SWIGN=1 QMC=1 LVARO=-1.735e-09 LVARL=0 LVARW=0 LAP=3.471e-08 WVARO=0 WVARL=0 WVARW=0 WOT=0 DLQ=3.537e-08 DWQ=3e-08 VFBO=-1.0717 VFBL=-0.03 VFBW=0 VFBLW=0 STVFBO=0.00057379 STVFBL=8.6794e-05 STVFBW=4.9309e-05 STVFBLW=-3.6436e-05 ST2VFBO=0 TOXO=6.945e-09 EPSROXO=3.9 NSUBO=4.2268e+23 NSUBW=0.01112 WSEG=5.362e-08 NPCK=8.0711e+23 NPCKW=-0.011403 WSEGP=1e-06 LPCK=8.3733e-09 LPCKW=0.077499 FOL1=0.065253 FOL2=0.010199 FACNEFFACO=1 FACNEFFACL=0 FACNEFFACW=0 FACNEFFACLW=0 GFACNUDO=1 GFACNUDL=0 GFACNUDLEXP=1 GFACNUDW=0 GFACNUDLW=0 VSBNUDO=0 DVSBNUDO=1 VNSUBO=0 NSLPO=0.05 DNSUBO=0.03585 DPHIBO=-0.077884807 DPHIBL=0.00526388544 DPHIBLEXP=2.1893 DPHIBW=-0.011141504 DPHIBLW=-9.3915789e-05 DELVTACO=0 DELVTACL=0 DELVTACLEXP=1 DELVTACW=0 DELVTACLW=0 NPO=1.092e+26 NPL=0.2188 TOXOVO=6.945e-09 TOXOVDO=2e-09 LOV=3.471e-08 LOVD=0 NOVO=1.99e+26 NOVDO=5e+25 CTO=-0.006328 CTL=0 CTLEXP=1 CTW=0.3006 CTLW=-0.01196 CTGO=0 CTBO=0 STCTO=1 CFL=0.00045884 CFLEXP=2.2055 CFW=0.45909 CFBO=1 CFDO=0 PSCEL=0 PSCELEXP=2 PSCEW=0 PSCEBO=0 PSCEDO=0 UO=0.018428 FBET1=0.15952 FBET1W=-2.1872 LP1=9.9822e-08 LP1W=-1.0871 FBET2=-2.7066 LP2=5.8401e-08 BETW1=-0.097534 BETW2=0.022314 WBET=7.9844e-10 STBETO=1.6489 STBETL=0.029528 STBETW=0.037078 STBETLW=0.046991 MUEO=1.7444601 MUEW=-0.06367 STMUEO=1.0816 THEMUO=1.0324 STTHEMUO=0.26337 CSO=0.18648 CSL=0.21903 CSLEXP=2.0917 CSW=0.0072837 CSLW=0.02 STCSO=2 THECSO=2 STTHECSO=0 XCORO=0.001363 XCORL=8 XCORW=0.0060537 XCORLW=0.058951 STXCORO=-6.939e-18 FETAO=1.2853 RSW1=1970 RSW2=-0.057547 STRSO=-0.24812 RSBO=0.074639 RSGO=0.23490984 THESATO=8.4917e-05 THESATL=0.0067396 THESATLEXP=2.395 THESATW=1.1549 THESATLW=-0.01 STTHESATO=3.0405 STTHESATL=-0.16001 STTHESATW=-0.96988 STTHESATLW=0.36213 THESATBO=0.1 THESATGO=0.6304 AXO=16.822 AXL=3.0092 ALPL=0.0058454 ALPLEXP=0.47562 ALPW=-0.065973 ALP1L1=4.4409e-16 ALP1LEXP=1.347 ALP1L2=1 ALP1W=2 ALP2L1=3.6779e-06 ALP2LEXP=0.2531 ALP2L2=2.2204e-15 ALP2W=0.9582 VPO=1.8436e-06 A1O=47.788 A1L=0.029145 A1W=0.01435 A2O=38.581 STA2O=-0.0049931 A3O=1.1753 A3L=-0.069795 A3W=0.0032538 A4O=0.12593 A4L=-0.07 A4W=-0.04811 GCOO=0 IGINVLW=0 IGOVW=0 IGOVDW=0 STIGO=2 GC2O=0.375 GC3O=0.063 CHIBO=3.1 AGIDLW=6e-10 AGIDLDW=0 BGIDLO=5.5970304 BGIDLDO=41 STBGIDLO=-0.0049461 STBGIDLDO=0 CGIDLO=0.23693 CGIDLDO=0 CGBOVL=-4.669e-16 CFRDW=0 FNTO=1 FNTEXCL=0 NFALW=1.3e+25 NFBLW=5289000000 NFCLW=2e-07 EFO=1.152 LINTNOI=2.5e-08 ALPNOI=2 WEDGE=1e-08 WEDGEW=0 VFBEDGEO=-1 STVFBEDGEO=0.0005 STVFBEDGEL=0 STVFBEDGEW=0 STVFBEDGELW=0 DPHIBEDGEO=0 DPHIBEDGEL=0 DPHIBEDGELEXP=1 DPHIBEDGEW=0 DPHIBEDGELW=0 NSUBEDGEO=5e+23 NSUBEDGEL=0 NSUBEDGELEXP=1 NSUBEDGEW=0 NSUBEDGELW=0 CTEDGEO=0 CTEDGEL=0 CTEDGELEXP=1 FBETEDGE=0 LPEDGE=1e-08 BETEDGEW=0 STBETEDGEO=1 STBETEDGEL=0 STBETEDGEW=0 STBETEDGELW=0 PSCEEDGEL=0 PSCEEDGELEXP=2 PSCEEDGEW=0 PSCEBEDGEO=0 PSCEDEDGEO=0 CFEDGEL=0 CFEDGELEXP=2 CFEDGEW=0 CFDEDGEO=0 CFBEDGEO=0 FNTEDGEO=1 NFAEDGELW=8e+22 NFBEDGELW=30000000 NFCEDGELW=0 EFEDGEO=1 SAREF=1e-06 SBREF=1e-06 WLOD=0 KUO=0 KVSAT=0 TKUO=0 LKUO=0 WKUO=0 PKUO=0 LLODKUO=0 WLODKUO=0 KVTHO=0 LKVTHO=0 WKVTHO=0 PKVTHO=0 LLODVTH=0 WLODVTH=0 STETAO=0 LODETAO=1 SCREF=1e-06 WEB=0 WEC=0 KVTHOWEO=0 KVTHOWEL=0 KVTHOWEW=0 KVTHOWELW=0 KUOWEO=0 KUOWEL=0 KUOWEW=0 KUOWELW=0 TRJ=21 SWJUNEXP=0 IMAX=0.0024527 FREV=1000 CJORBOT=0.0008095 CJORSTI=4.2583e-11 CJORGAT=3.1e-11 VBIRBOT=0.72606 VBIRSTI=0.69819 VBIRGAT=1.199 PBOT=0.33078 PSTI=0.22409 PGAT=0.4474 CJORBOTD=0.001 CJORSTID=1e-09 CJORGATD=1e-09 VBIRBOTD=1 VBIRSTID=1 VBIRGATD=1 PBOTD=0.5 PSTID=0.5 PGATD=0.5 PHIGBOT=1.0641 PHIGSTI=1.3946 PHIGGAT=1.83 IDSATRBOT=3.0606e-08 IDSATRSTI=3.6127e-15 IDSATRGAT=0 CSRHBOT=100 CSRHSTI=0.0001 CSRHGAT=0.0001 XJUNSTI=4.93e-08 XJUNGAT=7.062e-07 PHIGBOTD=1.16 PHIGSTID=1.16 PHIGGATD=1.16 IDSATRBOTD=1e-12 IDSATRSTID=1e-18 IDSATRGATD=1e-18 CSRHBOTD=100 CSRHSTID=0.0001 CSRHGATD=0.0001 XJUNSTID=1e-07 XJUNGATD=1e-07 CTATBOT=100 CTATSTI=0.0001 CTATGAT=0.0001 MEFFTATBOT=0.25 MEFFTATSTI=0.25 MEFFTATGAT=0.25 CTATBOTD=100 CTATSTID=0.0001 CTATGATD=0.0001 MEFFTATBOTD=0.25 MEFFTATSTID=0.25 MEFFTATGATD=0.25 CBBTBOT=1e-12 CBBTSTI=1e-21 CBBTGAT=1e-18 FBBTRBOT=1000000000 FBBTRSTI=1000000000 FBBTRGAT=1000000000 STFBBTBOT=-0.001 STFBBTSTI=-0.001 STFBBTGAT=-0.001 CBBTBOTD=1e-12 CBBTSTID=1e-18 CBBTGATD=1e-18 FBBTRBOTD=1000000000 FBBTRSTID=1000000000 FBBTRGATD=1000000000 STFBBTBOTD=-0.001 STFBBTSTID=-0.001 STFBBTGATD=-0.001 VBRBOT=10 VBRSTI=10 VBRGAT=10 PBRBOT=4 PBRSTI=4 PBRGAT=4 VBRBOTD=10 VBRSTID=10 VBRGATD=10 PBRBOTD=4 PBRSTID=4 PBRGATD=4 VJUNREF=2.5 FJUNQ=0.03 VJUNREFD=2.5 FJUNQD=0.03 RINT=0 RVPOLY=0 DLSIL=0 RSH=0 RSHD=0 CFRW=0 RSHG=40 RGO=15 RBULKO=500 RWELLO=250 RJUNSO=2500 RJUNDO=2500 SWSOA=0 VGS_MAX=3 VGD_MAX=3 VGB_MAX=3 VDS_MAX=3 VDB_MAX=1.6 VSB_MAX=1.6
model hvp_w4000n_l400n_ng1 PSP103VA TYPE=-1 TR=27 DTA=0 SWGEO=1 SWIGATE=1 SWIMPACT=1 SWGIDL=1 SWJUNCAP=3 SWJUNASYM=0 SWNUD=0 SWEDGE=0 SWDELVTAC=0 SWIGN=1 QMC=1 LVARO=-1.735e-09 LVARL=0 LVARW=0 LAP=3.471e-08 WVARO=0 WVARL=0 WVARW=0 WOT=0 DLQ=3.537e-08 DWQ=3e-08 VFBO=-1.0717 VFBL=-0.03 VFBW=0 VFBLW=0 STVFBO=0.00057379 STVFBL=8.6794e-05 STVFBW=4.9309e-05 STVFBLW=-3.6436e-05 ST2VFBO=0 TOXO=6.945e-09 EPSROXO=3.9 NSUBO=4.2268e+23 NSUBW=0.01112 WSEG=5.362e-08 NPCK=8.0711e+23 NPCKW=-0.011403 WSEGP=1e-06 LPCK=8.3733e-09 LPCKW=0.077499 FOL1=0.065253 FOL2=0.010199 FACNEFFACO=1 FACNEFFACL=0 FACNEFFACW=0 FACNEFFACLW=0 GFACNUDO=1 GFACNUDL=0 GFACNUDLEXP=1 GFACNUDW=0 GFACNUDLW=0 VSBNUDO=0 DVSBNUDO=1 VNSUBO=0 NSLPO=0.05 DNSUBO=0.03585 DPHIBO=-0.077884807 DPHIBL=0.00526388544 DPHIBLEXP=2.1893 DPHIBW=-0.011141504 DPHIBLW=-9.3915789e-05 DELVTACO=0 DELVTACL=0 DELVTACLEXP=1 DELVTACW=0 DELVTACLW=0 NPO=1.092e+26 NPL=0.2188 TOXOVO=6.945e-09 TOXOVDO=2e-09 LOV=3.471e-08 LOVD=0 NOVO=1.99e+26 NOVDO=5e+25 CTO=-0.006328 CTL=0 CTLEXP=1 CTW=0.3006 CTLW=-0.01196 CTGO=0 CTBO=0 STCTO=1 CFL=0.00045884 CFLEXP=2.2055 CFW=0.45909 CFBO=1 CFDO=0 PSCEL=0 PSCELEXP=2 PSCEW=0 PSCEBO=0 PSCEDO=0 UO=0.018428 FBET1=0.15952 FBET1W=-2.1872 LP1=9.9822e-08 LP1W=-1.0871 FBET2=-2.7066 LP2=5.8401e-08 BETW1=-0.097534 BETW2=0.022314 WBET=7.9844e-10 STBETO=1.6489 STBETL=0.029528 STBETW=0.037078 STBETLW=0.046991 MUEO=1.7444601 MUEW=-0.06367 STMUEO=1.0816 THEMUO=1.0324 STTHEMUO=0.26337 CSO=0.18648 CSL=0.21903 CSLEXP=2.0917 CSW=0.0072837 CSLW=0.02 STCSO=2 THECSO=2 STTHECSO=0 XCORO=0.001363 XCORL=8 XCORW=0.0060537 XCORLW=0.058951 STXCORO=-6.939e-18 FETAO=1.2853 RSW1=1970 RSW2=-0.057547 STRSO=-0.24812 RSBO=0.074639 RSGO=0.23490984 THESATO=8.4917e-05 THESATL=0.0067396 THESATLEXP=2.395 THESATW=1.1549 THESATLW=-0.01 STTHESATO=3.0405 STTHESATL=-0.16001 STTHESATW=-0.96988 STTHESATLW=0.36213 THESATBO=0.1 THESATGO=0.6304 AXO=16.822 AXL=3.0092 ALPL=0.0058454 ALPLEXP=0.47562 ALPW=-0.065973 ALP1L1=4.4409e-16 ALP1LEXP=1.347 ALP1L2=1 ALP1W=2 ALP2L1=3.6779e-06 ALP2LEXP=0.2531 ALP2L2=2.2204e-15 ALP2W=0.9582 VPO=1.8436e-06 A1O=47.788 A1L=0.029145 A1W=0.01435 A2O=38.581 STA2O=-0.0049931 A3O=1.1753 A3L=-0.069795 A3W=0.0032538 A4O=0.12593 A4L=-0.07 A4W=-0.04811 GCOO=0 IGINVLW=0 IGOVW=0 IGOVDW=0 STIGO=2 GC2O=0.375 GC3O=0.063 CHIBO=3.1 AGIDLW=6e-10 AGIDLDW=0 BGIDLO=5.5970304 BGIDLDO=41 STBGIDLO=-0.0049461 STBGIDLDO=0 CGIDLO=0.23693 CGIDLDO=0 CGBOVL=-4.669e-16 CFRDW=0 FNTO=1 FNTEXCL=0 NFALW=1.3e+25 NFBLW=5289000000 NFCLW=2e-07 EFO=1.152 LINTNOI=2.5e-08 ALPNOI=2 WEDGE=1e-08 WEDGEW=0 VFBEDGEO=-1 STVFBEDGEO=0.0005 STVFBEDGEL=0 STVFBEDGEW=0 STVFBEDGELW=0 DPHIBEDGEO=0 DPHIBEDGEL=0 DPHIBEDGELEXP=1 DPHIBEDGEW=0 DPHIBEDGELW=0 NSUBEDGEO=5e+23 NSUBEDGEL=0 NSUBEDGELEXP=1 NSUBEDGEW=0 NSUBEDGELW=0 CTEDGEO=0 CTEDGEL=0 CTEDGELEXP=1 FBETEDGE=0 LPEDGE=1e-08 BETEDGEW=0 STBETEDGEO=1 STBETEDGEL=0 STBETEDGEW=0 STBETEDGELW=0 PSCEEDGEL=0 PSCEEDGELEXP=2 PSCEEDGEW=0 PSCEBEDGEO=0 PSCEDEDGEO=0 CFEDGEL=0 CFEDGELEXP=2 CFEDGEW=0 CFDEDGEO=0 CFBEDGEO=0 FNTEDGEO=1 NFAEDGELW=8e+22 NFBEDGELW=30000000 NFCEDGELW=0 EFEDGEO=1 SAREF=1e-06 SBREF=1e-06 WLOD=0 KUO=0 KVSAT=0 TKUO=0 LKUO=0 WKUO=0 PKUO=0 LLODKUO=0 WLODKUO=0 KVTHO=0 LKVTHO=0 WKVTHO=0 PKVTHO=0 LLODVTH=0 WLODVTH=0 STETAO=0 LODETAO=1 SCREF=1e-06 WEB=0 WEC=0 KVTHOWEO=0 KVTHOWEL=0 KVTHOWEW=0 KVTHOWELW=0 KUOWEO=0 KUOWEL=0 KUOWEW=0 KUOWELW=0 TRJ=21 SWJUNEXP=0 IMAX=0.0024527 FREV=1000 CJORBOT=0.0008095 CJORSTI=4.2583e-11 CJORGAT=3.1e-11 VBIRBOT=0.72606 VBIRSTI=0.69819 VBIRGAT=1.199 PBOT=0.33078 PSTI=0.22409 PGAT=0.4474 CJORBOTD=0.001 CJORSTID=1e-09 CJORGATD=1e-09 VBIRBOTD=1 VBIRSTID=1 VBIRGATD=1 PBOTD=0.5 PSTID=0.5 PGATD=0.5 PHIGBOT=1.0641 PHIGSTI=1.3946 PHIGGAT=1.83 IDSATRBOT=3.0606e-08 IDSATRSTI=3.6127e-15 IDSATRGAT=0 CSRHBOT=100 CSRHSTI=0.0001 CSRHGAT=0.0001 XJUNSTI=4.93e-08 XJUNGAT=7.062e-07 PHIGBOTD=1.16 PHIGSTID=1.16 PHIGGATD=1.16 IDSATRBOTD=1e-12 IDSATRSTID=1e-18 IDSATRGATD=1e-18 CSRHBOTD=100 CSRHSTID=0.0001 CSRHGATD=0.0001 XJUNSTID=1e-07 XJUNGATD=1e-07 CTATBOT=100 CTATSTI=0.0001 CTATGAT=0.0001 MEFFTATBOT=0.25 MEFFTATSTI=0.25 MEFFTATGAT=0.25 CTATBOTD=100 CTATSTID=0.0001 CTATGATD=0.0001 MEFFTATBOTD=0.25 MEFFTATSTID=0.25 MEFFTATGATD=0.25 CBBTBOT=1e-12 CBBTSTI=1e-21 CBBTGAT=1e-18 FBBTRBOT=1000000000 FBBTRSTI=1000000000 FBBTRGAT=1000000000 STFBBTBOT=-0.001 STFBBTSTI=-0.001 STFBBTGAT=-0.001 CBBTBOTD=1e-12 CBBTSTID=1e-18 CBBTGATD=1e-18 FBBTRBOTD=1000000000 FBBTRSTID=1000000000 FBBTRGATD=1000000000 STFBBTBOTD=-0.001 STFBBTSTID=-0.001 STFBBTGATD=-0.001 VBRBOT=10 VBRSTI=10 VBRGAT=10 PBRBOT=4 PBRSTI=4 PBRGAT=4 VBRBOTD=10 VBRSTID=10 VBRGATD=10 PBRBOTD=4 PBRSTID=4 PBRGATD=4 VJUNREF=2.5 FJUNQ=0.03 VJUNREFD=2.5 FJUNQD=0.03 RINT=0 RVPOLY=0 DLSIL=0 RSH=0 RSHD=0 CFRW=0 RSHG=40 RGO=15 RBULKO=500 RWELLO=250 RJUNSO=500 RJUNDO=500 SWSOA=0 VGS_MAX=3 VGD_MAX=3 VGB_MAX=3 VDS_MAX=3 VDB_MAX=1.6 VSB_MAX=1.6
model hvp_w6892n_l400n_ng1 PSP103VA TYPE=-1 TR=27 DTA=0 SWGEO=1 SWIGATE=1 SWIMPACT=1 SWGIDL=1 SWJUNCAP=3 SWJUNASYM=0 SWNUD=0 SWEDGE=0 SWDELVTAC=0 SWIGN=1 QMC=1 LVARO=-1.735e-09 LVARL=0 LVARW=0 LAP=3.471e-08 WVARO=0 WVARL=0 WVARW=0 WOT=0 DLQ=3.537e-08 DWQ=3e-08 VFBO=-1.0717 VFBL=-0.03 VFBW=0 VFBLW=0 STVFBO=0.00057379 STVFBL=8.6794e-05 STVFBW=4.9309e-05 STVFBLW=-3.6436e-05 ST2VFBO=0 TOXO=6.945e-09 EPSROXO=3.9 NSUBO=4.2268e+23 NSUBW=0.01112 WSEG=5.362e-08 NPCK=8.0711e+23 NPCKW=-0.011403 WSEGP=1e-06 LPCK=8.3733e-09 LPCKW=0.077499 FOL1=0.065253 FOL2=0.010199 FACNEFFACO=1 FACNEFFACL=0 FACNEFFACW=0 FACNEFFACLW=0 GFACNUDO=1 GFACNUDL=0 GFACNUDLEXP=1 GFACNUDW=0 GFACNUDLW=0 VSBNUDO=0 DVSBNUDO=1 VNSUBO=0 NSLPO=0.05 DNSUBO=0.03585 DPHIBO=-0.077884807 DPHIBL=0.00526388544 DPHIBLEXP=2.1893 DPHIBW=-0.011141504 DPHIBLW=-9.3915789e-05 DELVTACO=0 DELVTACL=0 DELVTACLEXP=1 DELVTACW=0 DELVTACLW=0 NPO=1.092e+26 NPL=0.2188 TOXOVO=6.945e-09 TOXOVDO=2e-09 LOV=3.471e-08 LOVD=0 NOVO=1.99e+26 NOVDO=5e+25 CTO=-0.006328 CTL=0 CTLEXP=1 CTW=0.3006 CTLW=-0.01196 CTGO=0 CTBO=0 STCTO=1 CFL=0.00045884 CFLEXP=2.2055 CFW=0.45909 CFBO=1 CFDO=0 PSCEL=0 PSCELEXP=2 PSCEW=0 PSCEBO=0 PSCEDO=0 UO=0.018428 FBET1=0.15952 FBET1W=-2.1872 LP1=9.9822e-08 LP1W=-1.0871 FBET2=-2.7066 LP2=5.8401e-08 BETW1=-0.097534 BETW2=0.022314 WBET=7.9844e-10 STBETO=1.6489 STBETL=0.029528 STBETW=0.037078 STBETLW=0.046991 MUEO=1.7444601 MUEW=-0.06367 STMUEO=1.0816 THEMUO=1.0324 STTHEMUO=0.26337 CSO=0.18648 CSL=0.21903 CSLEXP=2.0917 CSW=0.0072837 CSLW=0.02 STCSO=2 THECSO=2 STTHECSO=0 XCORO=0.001363 XCORL=8 XCORW=0.0060537 XCORLW=0.058951 STXCORO=-6.939e-18 FETAO=1.2853 RSW1=1970 RSW2=-0.057547 STRSO=-0.24812 RSBO=0.074639 RSGO=0.23490984 THESATO=8.4917e-05 THESATL=0.0067396 THESATLEXP=2.395 THESATW=1.1549 THESATLW=-0.01 STTHESATO=3.0405 STTHESATL=-0.16001 STTHESATW=-0.96988 STTHESATLW=0.36213 THESATBO=0.1 THESATGO=0.6304 AXO=16.822 AXL=3.0092 ALPL=0.0058454 ALPLEXP=0.47562 ALPW=-0.065973 ALP1L1=4.4409e-16 ALP1LEXP=1.347 ALP1L2=1 ALP1W=2 ALP2L1=3.6779e-06 ALP2LEXP=0.2531 ALP2L2=2.2204e-15 ALP2W=0.9582 VPO=1.8436e-06 A1O=47.788 A1L=0.029145 A1W=0.01435 A2O=38.581 STA2O=-0.0049931 A3O=1.1753 A3L=-0.069795 A3W=0.0032538 A4O=0.12593 A4L=-0.07 A4W=-0.04811 GCOO=0 IGINVLW=0 IGOVW=0 IGOVDW=0 STIGO=2 GC2O=0.375 GC3O=0.063 CHIBO=3.1 AGIDLW=6e-10 AGIDLDW=0 BGIDLO=5.5970304 BGIDLDO=41 STBGIDLO=-0.0049461 STBGIDLDO=0 CGIDLO=0.23693 CGIDLDO=0 CGBOVL=-4.669e-16 CFRDW=0 FNTO=1 FNTEXCL=0 NFALW=1.3e+25 NFBLW=5289000000 NFCLW=2e-07 EFO=1.152 LINTNOI=2.5e-08 ALPNOI=2 WEDGE=1e-08 WEDGEW=0 VFBEDGEO=-1 STVFBEDGEO=0.0005 STVFBEDGEL=0 STVFBEDGEW=0 STVFBEDGELW=0 DPHIBEDGEO=0 DPHIBEDGEL=0 DPHIBEDGELEXP=1 DPHIBEDGEW=0 DPHIBEDGELW=0 NSUBEDGEO=5e+23 NSUBEDGEL=0 NSUBEDGELEXP=1 NSUBEDGEW=0 NSUBEDGELW=0 CTEDGEO=0 CTEDGEL=0 CTEDGELEXP=1 FBETEDGE=0 LPEDGE=1e-08 BETEDGEW=0 STBETEDGEO=1 STBETEDGEL=0 STBETEDGEW=0 STBETEDGELW=0 PSCEEDGEL=0 PSCEEDGELEXP=2 PSCEEDGEW=0 PSCEBEDGEO=0 PSCEDEDGEO=0 CFEDGEL=0 CFEDGELEXP=2 CFEDGEW=0 CFDEDGEO=0 CFBEDGEO=0 FNTEDGEO=1 NFAEDGELW=8e+22 NFBEDGELW=30000000 NFCEDGELW=0 EFEDGEO=1 SAREF=1e-06 SBREF=1e-06 WLOD=0 KUO=0 KVSAT=0 TKUO=0 LKUO=0 WKUO=0 PKUO=0 LLODKUO=0 WLODKUO=0 KVTHO=0 LKVTHO=0 WKVTHO=0 PKVTHO=0 LLODVTH=0 WLODVTH=0 STETAO=0 LODETAO=1 SCREF=1e-06 WEB=0 WEC=0 KVTHOWEO=0 KVTHOWEL=0 KVTHOWEW=0 KVTHOWELW=0 KUOWEO=0 KUOWEL=0 KUOWEW=0 KUOWELW=0 TRJ=21 SWJUNEXP=0 IMAX=0.0024527 FREV=1000 CJORBOT=0.0008095 CJORSTI=4.2583e-11 CJORGAT=3.1e-11 VBIRBOT=0.72606 VBIRSTI=0.69819 VBIRGAT=1.199 PBOT=0.33078 PSTI=0.22409 PGAT=0.4474 CJORBOTD=0.001 CJORSTID=1e-09 CJORGATD=1e-09 VBIRBOTD=1 VBIRSTID=1 VBIRGATD=1 PBOTD=0.5 PSTID=0.5 PGATD=0.5 PHIGBOT=1.0641 PHIGSTI=1.3946 PHIGGAT=1.83 IDSATRBOT=3.0606e-08 IDSATRSTI=3.6127e-15 IDSATRGAT=0 CSRHBOT=100 CSRHSTI=0.0001 CSRHGAT=0.0001 XJUNSTI=4.93e-08 XJUNGAT=7.062e-07 PHIGBOTD=1.16 PHIGSTID=1.16 PHIGGATD=1.16 IDSATRBOTD=1e-12 IDSATRSTID=1e-18 IDSATRGATD=1e-18 CSRHBOTD=100 CSRHSTID=0.0001 CSRHGATD=0.0001 XJUNSTID=1e-07 XJUNGATD=1e-07 CTATBOT=100 CTATSTI=0.0001 CTATGAT=0.0001 MEFFTATBOT=0.25 MEFFTATSTI=0.25 MEFFTATGAT=0.25 CTATBOTD=100 CTATSTID=0.0001 CTATGATD=0.0001 MEFFTATBOTD=0.25 MEFFTATSTID=0.25 MEFFTATGATD=0.25 CBBTBOT=1e-12 CBBTSTI=1e-21 CBBTGAT=1e-18 FBBTRBOT=1000000000 FBBTRSTI=1000000000 FBBTRGAT=1000000000 STFBBTBOT=-0.001 STFBBTSTI=-0.001 STFBBTGAT=-0.001 CBBTBOTD=1e-12 CBBTSTID=1e-18 CBBTGATD=1e-18 FBBTRBOTD=1000000000 FBBTRSTID=1000000000 FBBTRGATD=1000000000 STFBBTBOTD=-0.001 STFBBTSTID=-0.001 STFBBTGATD=-0.001 VBRBOT=10 VBRSTI=10 VBRGAT=10 PBRBOT=4 PBRSTI=4 PBRGAT=4 VBRBOTD=10 VBRSTID=10 VBRGATD=10 PBRBOTD=4 PBRSTID=4 PBRGATD=4 VJUNREF=2.5 FJUNQ=0.03 VJUNREFD=2.5 FJUNQD=0.03 RINT=0 RVPOLY=0 DLSIL=0 RSH=0 RSHD=0 CFRW=0 RSHG=40 RGO=15 RBULKO=290.1922685 RWELLO=145.0961342 RJUNSO=290.1922685 RJUNDO=290.1922685 SWSOA=0 VGS_MAX=3 VGD_MAX=3 VGB_MAX=3 VDS_MAX=3 VDB_MAX=1.6 VSB_MAX=1.6
model hvp_w7251n_l400n_ng1 PSP103VA TYPE=-1 TR=27 DTA=0 SWGEO=1 SWIGATE=1 SWIMPACT=1 SWGIDL=1 SWJUNCAP=3 SWJUNASYM=0 SWNUD=0 SWEDGE=0 SWDELVTAC=0 SWIGN=1 QMC=1 LVARO=-1.735e-09 LVARL=0 LVARW=0 LAP=3.471e-08 WVARO=0 WVARL=0 WVARW=0 WOT=0 DLQ=3.537e-08 DWQ=3e-08 VFBO=-1.0717 VFBL=-0.03 VFBW=0 VFBLW=0 STVFBO=0.00057379 STVFBL=8.6794e-05 STVFBW=4.9309e-05 STVFBLW=-3.6436e-05 ST2VFBO=0 TOXO=6.945e-09 EPSROXO=3.9 NSUBO=4.2268e+23 NSUBW=0.01112 WSEG=5.362e-08 NPCK=8.0711e+23 NPCKW=-0.011403 WSEGP=1e-06 LPCK=8.3733e-09 LPCKW=0.077499 FOL1=0.065253 FOL2=0.010199 FACNEFFACO=1 FACNEFFACL=0 FACNEFFACW=0 FACNEFFACLW=0 GFACNUDO=1 GFACNUDL=0 GFACNUDLEXP=1 GFACNUDW=0 GFACNUDLW=0 VSBNUDO=0 DVSBNUDO=1 VNSUBO=0 NSLPO=0.05 DNSUBO=0.03585 DPHIBO=-0.077884807 DPHIBL=0.00526388544 DPHIBLEXP=2.1893 DPHIBW=-0.011141504 DPHIBLW=-9.3915789e-05 DELVTACO=0 DELVTACL=0 DELVTACLEXP=1 DELVTACW=0 DELVTACLW=0 NPO=1.092e+26 NPL=0.2188 TOXOVO=6.945e-09 TOXOVDO=2e-09 LOV=3.471e-08 LOVD=0 NOVO=1.99e+26 NOVDO=5e+25 CTO=-0.006328 CTL=0 CTLEXP=1 CTW=0.3006 CTLW=-0.01196 CTGO=0 CTBO=0 STCTO=1 CFL=0.00045884 CFLEXP=2.2055 CFW=0.45909 CFBO=1 CFDO=0 PSCEL=0 PSCELEXP=2 PSCEW=0 PSCEBO=0 PSCEDO=0 UO=0.018428 FBET1=0.15952 FBET1W=-2.1872 LP1=9.9822e-08 LP1W=-1.0871 FBET2=-2.7066 LP2=5.8401e-08 BETW1=-0.097534 BETW2=0.022314 WBET=7.9844e-10 STBETO=1.6489 STBETL=0.029528 STBETW=0.037078 STBETLW=0.046991 MUEO=1.7444601 MUEW=-0.06367 STMUEO=1.0816 THEMUO=1.0324 STTHEMUO=0.26337 CSO=0.18648 CSL=0.21903 CSLEXP=2.0917 CSW=0.0072837 CSLW=0.02 STCSO=2 THECSO=2 STTHECSO=0 XCORO=0.001363 XCORL=8 XCORW=0.0060537 XCORLW=0.058951 STXCORO=-6.939e-18 FETAO=1.2853 RSW1=1970 RSW2=-0.057547 STRSO=-0.24812 RSBO=0.074639 RSGO=0.23490984 THESATO=8.4917e-05 THESATL=0.0067396 THESATLEXP=2.395 THESATW=1.1549 THESATLW=-0.01 STTHESATO=3.0405 STTHESATL=-0.16001 STTHESATW=-0.96988 STTHESATLW=0.36213 THESATBO=0.1 THESATGO=0.6304 AXO=16.822 AXL=3.0092 ALPL=0.0058454 ALPLEXP=0.47562 ALPW=-0.065973 ALP1L1=4.4409e-16 ALP1LEXP=1.347 ALP1L2=1 ALP1W=2 ALP2L1=3.6779e-06 ALP2LEXP=0.2531 ALP2L2=2.2204e-15 ALP2W=0.9582 VPO=1.8436e-06 A1O=47.788 A1L=0.029145 A1W=0.01435 A2O=38.581 STA2O=-0.0049931 A3O=1.1753 A3L=-0.069795 A3W=0.0032538 A4O=0.12593 A4L=-0.07 A4W=-0.04811 GCOO=0 IGINVLW=0 IGOVW=0 IGOVDW=0 STIGO=2 GC2O=0.375 GC3O=0.063 CHIBO=3.1 AGIDLW=6e-10 AGIDLDW=0 BGIDLO=5.5970304 BGIDLDO=41 STBGIDLO=-0.0049461 STBGIDLDO=0 CGIDLO=0.23693 CGIDLDO=0 CGBOVL=-4.669e-16 CFRDW=0 FNTO=1 FNTEXCL=0 NFALW=1.3e+25 NFBLW=5289000000 NFCLW=2e-07 EFO=1.152 LINTNOI=2.5e-08 ALPNOI=2 WEDGE=1e-08 WEDGEW=0 VFBEDGEO=-1 STVFBEDGEO=0.0005 STVFBEDGEL=0 STVFBEDGEW=0 STVFBEDGELW=0 DPHIBEDGEO=0 DPHIBEDGEL=0 DPHIBEDGELEXP=1 DPHIBEDGEW=0 DPHIBEDGELW=0 NSUBEDGEO=5e+23 NSUBEDGEL=0 NSUBEDGELEXP=1 NSUBEDGEW=0 NSUBEDGELW=0 CTEDGEO=0 CTEDGEL=0 CTEDGELEXP=1 FBETEDGE=0 LPEDGE=1e-08 BETEDGEW=0 STBETEDGEO=1 STBETEDGEL=0 STBETEDGEW=0 STBETEDGELW=0 PSCEEDGEL=0 PSCEEDGELEXP=2 PSCEEDGEW=0 PSCEBEDGEO=0 PSCEDEDGEO=0 CFEDGEL=0 CFEDGELEXP=2 CFEDGEW=0 CFDEDGEO=0 CFBEDGEO=0 FNTEDGEO=1 NFAEDGELW=8e+22 NFBEDGELW=30000000 NFCEDGELW=0 EFEDGEO=1 SAREF=1e-06 SBREF=1e-06 WLOD=0 KUO=0 KVSAT=0 TKUO=0 LKUO=0 WKUO=0 PKUO=0 LLODKUO=0 WLODKUO=0 KVTHO=0 LKVTHO=0 WKVTHO=0 PKVTHO=0 LLODVTH=0 WLODVTH=0 STETAO=0 LODETAO=1 SCREF=1e-06 WEB=0 WEC=0 KVTHOWEO=0 KVTHOWEL=0 KVTHOWEW=0 KVTHOWELW=0 KUOWEO=0 KUOWEL=0 KUOWEW=0 KUOWELW=0 TRJ=21 SWJUNEXP=0 IMAX=0.0024527 FREV=1000 CJORBOT=0.0008095 CJORSTI=4.2583e-11 CJORGAT=3.1e-11 VBIRBOT=0.72606 VBIRSTI=0.69819 VBIRGAT=1.199 PBOT=0.33078 PSTI=0.22409 PGAT=0.4474 CJORBOTD=0.001 CJORSTID=1e-09 CJORGATD=1e-09 VBIRBOTD=1 VBIRSTID=1 VBIRGATD=1 PBOTD=0.5 PSTID=0.5 PGATD=0.5 PHIGBOT=1.0641 PHIGSTI=1.3946 PHIGGAT=1.83 IDSATRBOT=3.0606e-08 IDSATRSTI=3.6127e-15 IDSATRGAT=0 CSRHBOT=100 CSRHSTI=0.0001 CSRHGAT=0.0001 XJUNSTI=4.93e-08 XJUNGAT=7.062e-07 PHIGBOTD=1.16 PHIGSTID=1.16 PHIGGATD=1.16 IDSATRBOTD=1e-12 IDSATRSTID=1e-18 IDSATRGATD=1e-18 CSRHBOTD=100 CSRHSTID=0.0001 CSRHGATD=0.0001 XJUNSTID=1e-07 XJUNGATD=1e-07 CTATBOT=100 CTATSTI=0.0001 CTATGAT=0.0001 MEFFTATBOT=0.25 MEFFTATSTI=0.25 MEFFTATGAT=0.25 CTATBOTD=100 CTATSTID=0.0001 CTATGATD=0.0001 MEFFTATBOTD=0.25 MEFFTATSTID=0.25 MEFFTATGATD=0.25 CBBTBOT=1e-12 CBBTSTI=1e-21 CBBTGAT=1e-18 FBBTRBOT=1000000000 FBBTRSTI=1000000000 FBBTRGAT=1000000000 STFBBTBOT=-0.001 STFBBTSTI=-0.001 STFBBTGAT=-0.001 CBBTBOTD=1e-12 CBBTSTID=1e-18 CBBTGATD=1e-18 FBBTRBOTD=1000000000 FBBTRSTID=1000000000 FBBTRGATD=1000000000 STFBBTBOTD=-0.001 STFBBTSTID=-0.001 STFBBTGATD=-0.001 VBRBOT=10 VBRSTI=10 VBRGAT=10 PBRBOT=4 PBRSTI=4 PBRGAT=4 VBRBOTD=10 VBRSTID=10 VBRGATD=10 PBRBOTD=4 PBRSTID=4 PBRGATD=4 VJUNREF=2.5 FJUNQ=0.03 VJUNREFD=2.5 FJUNQD=0.03 RINT=0 RVPOLY=0 DLSIL=0 RSH=0 RSHD=0 CFRW=0 RSHG=40 RGO=15 RBULKO=275.8259828 RWELLO=137.9129914 RJUNSO=275.8259828 RJUNDO=275.8259828 SWSOA=0 VGS_MAX=3 VGD_MAX=3 VGB_MAX=3 VDS_MAX=3 VDB_MAX=1.6 VSB_MAX=1.6
model hvp_w7545n_l400n_ng1 PSP103VA TYPE=-1 TR=27 DTA=0 SWGEO=1 SWIGATE=1 SWIMPACT=1 SWGIDL=1 SWJUNCAP=3 SWJUNASYM=0 SWNUD=0 SWEDGE=0 SWDELVTAC=0 SWIGN=1 QMC=1 LVARO=-1.735e-09 LVARL=0 LVARW=0 LAP=3.471e-08 WVARO=0 WVARL=0 WVARW=0 WOT=0 DLQ=3.537e-08 DWQ=3e-08 VFBO=-1.0717 VFBL=-0.03 VFBW=0 VFBLW=0 STVFBO=0.00057379 STVFBL=8.6794e-05 STVFBW=4.9309e-05 STVFBLW=-3.6436e-05 ST2VFBO=0 TOXO=6.945e-09 EPSROXO=3.9 NSUBO=4.2268e+23 NSUBW=0.01112 WSEG=5.362e-08 NPCK=8.0711e+23 NPCKW=-0.011403 WSEGP=1e-06 LPCK=8.3733e-09 LPCKW=0.077499 FOL1=0.065253 FOL2=0.010199 FACNEFFACO=1 FACNEFFACL=0 FACNEFFACW=0 FACNEFFACLW=0 GFACNUDO=1 GFACNUDL=0 GFACNUDLEXP=1 GFACNUDW=0 GFACNUDLW=0 VSBNUDO=0 DVSBNUDO=1 VNSUBO=0 NSLPO=0.05 DNSUBO=0.03585 DPHIBO=-0.077884807 DPHIBL=0.00526388544 DPHIBLEXP=2.1893 DPHIBW=-0.011141504 DPHIBLW=-9.3915789e-05 DELVTACO=0 DELVTACL=0 DELVTACLEXP=1 DELVTACW=0 DELVTACLW=0 NPO=1.092e+26 NPL=0.2188 TOXOVO=6.945e-09 TOXOVDO=2e-09 LOV=3.471e-08 LOVD=0 NOVO=1.99e+26 NOVDO=5e+25 CTO=-0.006328 CTL=0 CTLEXP=1 CTW=0.3006 CTLW=-0.01196 CTGO=0 CTBO=0 STCTO=1 CFL=0.00045884 CFLEXP=2.2055 CFW=0.45909 CFBO=1 CFDO=0 PSCEL=0 PSCELEXP=2 PSCEW=0 PSCEBO=0 PSCEDO=0 UO=0.018428 FBET1=0.15952 FBET1W=-2.1872 LP1=9.9822e-08 LP1W=-1.0871 FBET2=-2.7066 LP2=5.8401e-08 BETW1=-0.097534 BETW2=0.022314 WBET=7.9844e-10 STBETO=1.6489 STBETL=0.029528 STBETW=0.037078 STBETLW=0.046991 MUEO=1.7444601 MUEW=-0.06367 STMUEO=1.0816 THEMUO=1.0324 STTHEMUO=0.26337 CSO=0.18648 CSL=0.21903 CSLEXP=2.0917 CSW=0.0072837 CSLW=0.02 STCSO=2 THECSO=2 STTHECSO=0 XCORO=0.001363 XCORL=8 XCORW=0.0060537 XCORLW=0.058951 STXCORO=-6.939e-18 FETAO=1.2853 RSW1=1970 RSW2=-0.057547 STRSO=-0.24812 RSBO=0.074639 RSGO=0.23490984 THESATO=8.4917e-05 THESATL=0.0067396 THESATLEXP=2.395 THESATW=1.1549 THESATLW=-0.01 STTHESATO=3.0405 STTHESATL=-0.16001 STTHESATW=-0.96988 STTHESATLW=0.36213 THESATBO=0.1 THESATGO=0.6304 AXO=16.822 AXL=3.0092 ALPL=0.0058454 ALPLEXP=0.47562 ALPW=-0.065973 ALP1L1=4.4409e-16 ALP1LEXP=1.347 ALP1L2=1 ALP1W=2 ALP2L1=3.6779e-06 ALP2LEXP=0.2531 ALP2L2=2.2204e-15 ALP2W=0.9582 VPO=1.8436e-06 A1O=47.788 A1L=0.029145 A1W=0.01435 A2O=38.581 STA2O=-0.0049931 A3O=1.1753 A3L=-0.069795 A3W=0.0032538 A4O=0.12593 A4L=-0.07 A4W=-0.04811 GCOO=0 IGINVLW=0 IGOVW=0 IGOVDW=0 STIGO=2 GC2O=0.375 GC3O=0.063 CHIBO=3.1 AGIDLW=6e-10 AGIDLDW=0 BGIDLO=5.5970304 BGIDLDO=41 STBGIDLO=-0.0049461 STBGIDLDO=0 CGIDLO=0.23693 CGIDLDO=0 CGBOVL=-4.669e-16 CFRDW=0 FNTO=1 FNTEXCL=0 NFALW=1.3e+25 NFBLW=5289000000 NFCLW=2e-07 EFO=1.152 LINTNOI=2.5e-08 ALPNOI=2 WEDGE=1e-08 WEDGEW=0 VFBEDGEO=-1 STVFBEDGEO=0.0005 STVFBEDGEL=0 STVFBEDGEW=0 STVFBEDGELW=0 DPHIBEDGEO=0 DPHIBEDGEL=0 DPHIBEDGELEXP=1 DPHIBEDGEW=0 DPHIBEDGELW=0 NSUBEDGEO=5e+23 NSUBEDGEL=0 NSUBEDGELEXP=1 NSUBEDGEW=0 NSUBEDGELW=0 CTEDGEO=0 CTEDGEL=0 CTEDGELEXP=1 FBETEDGE=0 LPEDGE=1e-08 BETEDGEW=0 STBETEDGEO=1 STBETEDGEL=0 STBETEDGEW=0 STBETEDGELW=0 PSCEEDGEL=0 PSCEEDGELEXP=2 PSCEEDGEW=0 PSCEBEDGEO=0 PSCEDEDGEO=0 CFEDGEL=0 CFEDGELEXP=2 CFEDGEW=0 CFDEDGEO=0 CFBEDGEO=0 FNTEDGEO=1 NFAEDGELW=8e+22 NFBEDGELW=30000000 NFCEDGELW=0 EFEDGEO=1 SAREF=1e-06 SBREF=1e-06 WLOD=0 KUO=0 KVSAT=0 TKUO=0 LKUO=0 WKUO=0 PKUO=0 LLODKUO=0 WLODKUO=0 KVTHO=0 LKVTHO=0 WKVTHO=0 PKVTHO=0 LLODVTH=0 WLODVTH=0 STETAO=0 LODETAO=1 SCREF=1e-06 WEB=0 WEC=0 KVTHOWEO=0 KVTHOWEL=0 KVTHOWEW=0 KVTHOWELW=0 KUOWEO=0 KUOWEL=0 KUOWEW=0 KUOWELW=0 TRJ=21 SWJUNEXP=0 IMAX=0.0024527 FREV=1000 CJORBOT=0.0008095 CJORSTI=4.2583e-11 CJORGAT=3.1e-11 VBIRBOT=0.72606 VBIRSTI=0.69819 VBIRGAT=1.199 PBOT=0.33078 PSTI=0.22409 PGAT=0.4474 CJORBOTD=0.001 CJORSTID=1e-09 CJORGATD=1e-09 VBIRBOTD=1 VBIRSTID=1 VBIRGATD=1 PBOTD=0.5 PSTID=0.5 PGATD=0.5 PHIGBOT=1.0641 PHIGSTI=1.3946 PHIGGAT=1.83 IDSATRBOT=3.0606e-08 IDSATRSTI=3.6127e-15 IDSATRGAT=0 CSRHBOT=100 CSRHSTI=0.0001 CSRHGAT=0.0001 XJUNSTI=4.93e-08 XJUNGAT=7.062e-07 PHIGBOTD=1.16 PHIGSTID=1.16 PHIGGATD=1.16 IDSATRBOTD=1e-12 IDSATRSTID=1e-18 IDSATRGATD=1e-18 CSRHBOTD=100 CSRHSTID=0.0001 CSRHGATD=0.0001 XJUNSTID=1e-07 XJUNGATD=1e-07 CTATBOT=100 CTATSTI=0.0001 CTATGAT=0.0001 MEFFTATBOT=0.25 MEFFTATSTI=0.25 MEFFTATGAT=0.25 CTATBOTD=100 CTATSTID=0.0001 CTATGATD=0.0001 MEFFTATBOTD=0.25 MEFFTATSTID=0.25 MEFFTATGATD=0.25 CBBTBOT=1e-12 CBBTSTI=1e-21 CBBTGAT=1e-18 FBBTRBOT=1000000000 FBBTRSTI=1000000000 FBBTRGAT=1000000000 STFBBTBOT=-0.001 STFBBTSTI=-0.001 STFBBTGAT=-0.001 CBBTBOTD=1e-12 CBBTSTID=1e-18 CBBTGATD=1e-18 FBBTRBOTD=1000000000 FBBTRSTID=1000000000 FBBTRGATD=1000000000 STFBBTBOTD=-0.001 STFBBTSTID=-0.001 STFBBTGATD=-0.001 VBRBOT=10 VBRSTI=10 VBRGAT=10 PBRBOT=4 PBRSTI=4 PBRGAT=4 VBRBOTD=10 VBRSTID=10 VBRGATD=10 PBRBOTD=4 PBRSTID=4 PBRGATD=4 VJUNREF=2.5 FJUNQ=0.03 VJUNREFD=2.5 FJUNQD=0.03 RINT=0 RVPOLY=0 DLSIL=0 RSH=0 RSHD=0 CFRW=0 RSHG=40 RGO=15 RBULKO=265.0736435 RWELLO=132.5368217 RJUNSO=265.0736435 RJUNDO=265.0736435 SWSOA=0 VGS_MAX=3 VGD_MAX=3 VGB_MAX=3 VDS_MAX=3 VDB_MAX=1.6 VSB_MAX=1.6
model hvp_w8000n_l1000n_ng1 PSP103VA TYPE=-1 TR=27 DTA=0 SWGEO=1 SWIGATE=1 SWIMPACT=1 SWGIDL=1 SWJUNCAP=3 SWJUNASYM=0 SWNUD=0 SWEDGE=0 SWDELVTAC=0 SWIGN=1 QMC=1 LVARO=-1.735e-09 LVARL=0 LVARW=0 LAP=3.471e-08 WVARO=0 WVARL=0 WVARW=0 WOT=0 DLQ=3.537e-08 DWQ=3e-08 VFBO=-1.0717 VFBL=-0.03 VFBW=0 VFBLW=0 STVFBO=0.00057379 STVFBL=8.6794e-05 STVFBW=4.9309e-05 STVFBLW=-3.6436e-05 ST2VFBO=0 TOXO=6.945e-09 EPSROXO=3.9 NSUBO=4.2268e+23 NSUBW=0.01112 WSEG=5.362e-08 NPCK=8.0711e+23 NPCKW=-0.011403 WSEGP=1e-06 LPCK=8.3733e-09 LPCKW=0.077499 FOL1=0.065253 FOL2=0.010199 FACNEFFACO=1 FACNEFFACL=0 FACNEFFACW=0 FACNEFFACLW=0 GFACNUDO=1 GFACNUDL=0 GFACNUDLEXP=1 GFACNUDW=0 GFACNUDLW=0 VSBNUDO=0 DVSBNUDO=1 VNSUBO=0 NSLPO=0.05 DNSUBO=0.03585 DPHIBO=-0.077884807 DPHIBL=0.00526388544 DPHIBLEXP=2.1893 DPHIBW=-0.011141504 DPHIBLW=-9.3915789e-05 DELVTACO=0 DELVTACL=0 DELVTACLEXP=1 DELVTACW=0 DELVTACLW=0 NPO=1.092e+26 NPL=0.2188 TOXOVO=6.945e-09 TOXOVDO=2e-09 LOV=3.471e-08 LOVD=0 NOVO=1.99e+26 NOVDO=5e+25 CTO=-0.006328 CTL=0 CTLEXP=1 CTW=0.3006 CTLW=-0.01196 CTGO=0 CTBO=0 STCTO=1 CFL=0.00045884 CFLEXP=2.2055 CFW=0.45909 CFBO=1 CFDO=0 PSCEL=0 PSCELEXP=2 PSCEW=0 PSCEBO=0 PSCEDO=0 UO=0.018428 FBET1=0.15952 FBET1W=-2.1872 LP1=9.9822e-08 LP1W=-1.0871 FBET2=-2.7066 LP2=5.8401e-08 BETW1=-0.097534 BETW2=0.022314 WBET=7.9844e-10 STBETO=1.6489 STBETL=0.029528 STBETW=0.037078 STBETLW=0.046991 MUEO=1.7444601 MUEW=-0.06367 STMUEO=1.0816 THEMUO=1.0324 STTHEMUO=0.26337 CSO=0.18648 CSL=0.21903 CSLEXP=2.0917 CSW=0.0072837 CSLW=0.02 STCSO=2 THECSO=2 STTHECSO=0 XCORO=0.001363 XCORL=8 XCORW=0.0060537 XCORLW=0.058951 STXCORO=-6.939e-18 FETAO=1.2853 RSW1=1970 RSW2=-0.057547 STRSO=-0.24812 RSBO=0.074639 RSGO=0.23490984 THESATO=8.4917e-05 THESATL=0.0067396 THESATLEXP=2.395 THESATW=1.1549 THESATLW=-0.01 STTHESATO=3.0405 STTHESATL=-0.16001 STTHESATW=-0.96988 STTHESATLW=0.36213 THESATBO=0.1 THESATGO=0.6304 AXO=16.822 AXL=3.0092 ALPL=0.0058454 ALPLEXP=0.47562 ALPW=-0.065973 ALP1L1=4.4409e-16 ALP1LEXP=1.347 ALP1L2=1 ALP1W=2 ALP2L1=3.6779e-06 ALP2LEXP=0.2531 ALP2L2=2.2204e-15 ALP2W=0.9582 VPO=1.8436e-06 A1O=47.788 A1L=0.029145 A1W=0.01435 A2O=38.581 STA2O=-0.0049931 A3O=1.1753 A3L=-0.069795 A3W=0.0032538 A4O=0.12593 A4L=-0.07 A4W=-0.04811 GCOO=0 IGINVLW=0 IGOVW=0 IGOVDW=0 STIGO=2 GC2O=0.375 GC3O=0.063 CHIBO=3.1 AGIDLW=6e-10 AGIDLDW=0 BGIDLO=5.5970304 BGIDLDO=41 STBGIDLO=-0.0049461 STBGIDLDO=0 CGIDLO=0.23693 CGIDLDO=0 CGBOVL=-4.669e-16 CFRDW=0 FNTO=1 FNTEXCL=0 NFALW=1.3e+25 NFBLW=5289000000 NFCLW=2e-07 EFO=1.152 LINTNOI=2.5e-08 ALPNOI=2 WEDGE=1e-08 WEDGEW=0 VFBEDGEO=-1 STVFBEDGEO=0.0005 STVFBEDGEL=0 STVFBEDGEW=0 STVFBEDGELW=0 DPHIBEDGEO=0 DPHIBEDGEL=0 DPHIBEDGELEXP=1 DPHIBEDGEW=0 DPHIBEDGELW=0 NSUBEDGEO=5e+23 NSUBEDGEL=0 NSUBEDGELEXP=1 NSUBEDGEW=0 NSUBEDGELW=0 CTEDGEO=0 CTEDGEL=0 CTEDGELEXP=1 FBETEDGE=0 LPEDGE=1e-08 BETEDGEW=0 STBETEDGEO=1 STBETEDGEL=0 STBETEDGEW=0 STBETEDGELW=0 PSCEEDGEL=0 PSCEEDGELEXP=2 PSCEEDGEW=0 PSCEBEDGEO=0 PSCEDEDGEO=0 CFEDGEL=0 CFEDGELEXP=2 CFEDGEW=0 CFDEDGEO=0 CFBEDGEO=0 FNTEDGEO=1 NFAEDGELW=8e+22 NFBEDGELW=30000000 NFCEDGELW=0 EFEDGEO=1 SAREF=1e-06 SBREF=1e-06 WLOD=0 KUO=0 KVSAT=0 TKUO=0 LKUO=0 WKUO=0 PKUO=0 LLODKUO=0 WLODKUO=0 KVTHO=0 LKVTHO=0 WKVTHO=0 PKVTHO=0 LLODVTH=0 WLODVTH=0 STETAO=0 LODETAO=1 SCREF=1e-06 WEB=0 WEC=0 KVTHOWEO=0 KVTHOWEL=0 KVTHOWEW=0 KVTHOWELW=0 KUOWEO=0 KUOWEL=0 KUOWEW=0 KUOWELW=0 TRJ=21 SWJUNEXP=0 IMAX=0.0024527 FREV=1000 CJORBOT=0.0008095 CJORSTI=4.2583e-11 CJORGAT=3.1e-11 VBIRBOT=0.72606 VBIRSTI=0.69819 VBIRGAT=1.199 PBOT=0.33078 PSTI=0.22409 PGAT=0.4474 CJORBOTD=0.001 CJORSTID=1e-09 CJORGATD=1e-09 VBIRBOTD=1 VBIRSTID=1 VBIRGATD=1 PBOTD=0.5 PSTID=0.5 PGATD=0.5 PHIGBOT=1.0641 PHIGSTI=1.3946 PHIGGAT=1.83 IDSATRBOT=3.0606e-08 IDSATRSTI=3.6127e-15 IDSATRGAT=0 CSRHBOT=100 CSRHSTI=0.0001 CSRHGAT=0.0001 XJUNSTI=4.93e-08 XJUNGAT=7.062e-07 PHIGBOTD=1.16 PHIGSTID=1.16 PHIGGATD=1.16 IDSATRBOTD=1e-12 IDSATRSTID=1e-18 IDSATRGATD=1e-18 CSRHBOTD=100 CSRHSTID=0.0001 CSRHGATD=0.0001 XJUNSTID=1e-07 XJUNGATD=1e-07 CTATBOT=100 CTATSTI=0.0001 CTATGAT=0.0001 MEFFTATBOT=0.25 MEFFTATSTI=0.25 MEFFTATGAT=0.25 CTATBOTD=100 CTATSTID=0.0001 CTATGATD=0.0001 MEFFTATBOTD=0.25 MEFFTATSTID=0.25 MEFFTATGATD=0.25 CBBTBOT=1e-12 CBBTSTI=1e-21 CBBTGAT=1e-18 FBBTRBOT=1000000000 FBBTRSTI=1000000000 FBBTRGAT=1000000000 STFBBTBOT=-0.001 STFBBTSTI=-0.001 STFBBTGAT=-0.001 CBBTBOTD=1e-12 CBBTSTID=1e-18 CBBTGATD=1e-18 FBBTRBOTD=1000000000 FBBTRSTID=1000000000 FBBTRGATD=1000000000 STFBBTBOTD=-0.001 STFBBTSTID=-0.001 STFBBTGATD=-0.001 VBRBOT=10 VBRSTI=10 VBRGAT=10 PBRBOT=4 PBRSTI=4 PBRGAT=4 VBRBOTD=10 VBRSTID=10 VBRGATD=10 PBRBOTD=4 PBRSTID=4 PBRGATD=4 VJUNREF=2.5 FJUNQ=0.03 VJUNREFD=2.5 FJUNQD=0.03 RINT=0 RVPOLY=0 DLSIL=0 RSH=0 RSHD=0 CFRW=0 RSHG=40 RGO=15 RBULKO=250 RWELLO=125 RJUNSO=625 RJUNDO=625 SWSOA=0 VGS_MAX=3 VGD_MAX=3 VGB_MAX=3 VDS_MAX=3 VDB_MAX=1.6 VSB_MAX=1.6
model hvp_w8000n_l2000n_ng1 PSP103VA TYPE=-1 TR=27 DTA=0 SWGEO=1 SWIGATE=1 SWIMPACT=1 SWGIDL=1 SWJUNCAP=3 SWJUNASYM=0 SWNUD=0 SWEDGE=0 SWDELVTAC=0 SWIGN=1 QMC=1 LVARO=-1.735e-09 LVARL=0 LVARW=0 LAP=3.471e-08 WVARO=0 WVARL=0 WVARW=0 WOT=0 DLQ=3.537e-08 DWQ=3e-08 VFBO=-1.0717 VFBL=-0.03 VFBW=0 VFBLW=0 STVFBO=0.00057379 STVFBL=8.6794e-05 STVFBW=4.9309e-05 STVFBLW=-3.6436e-05 ST2VFBO=0 TOXO=6.945e-09 EPSROXO=3.9 NSUBO=4.2268e+23 NSUBW=0.01112 WSEG=5.362e-08 NPCK=8.0711e+23 NPCKW=-0.011403 WSEGP=1e-06 LPCK=8.3733e-09 LPCKW=0.077499 FOL1=0.065253 FOL2=0.010199 FACNEFFACO=1 FACNEFFACL=0 FACNEFFACW=0 FACNEFFACLW=0 GFACNUDO=1 GFACNUDL=0 GFACNUDLEXP=1 GFACNUDW=0 GFACNUDLW=0 VSBNUDO=0 DVSBNUDO=1 VNSUBO=0 NSLPO=0.05 DNSUBO=0.03585 DPHIBO=-0.077884807 DPHIBL=0.00526388544 DPHIBLEXP=2.1893 DPHIBW=-0.011141504 DPHIBLW=-9.3915789e-05 DELVTACO=0 DELVTACL=0 DELVTACLEXP=1 DELVTACW=0 DELVTACLW=0 NPO=1.092e+26 NPL=0.2188 TOXOVO=6.945e-09 TOXOVDO=2e-09 LOV=3.471e-08 LOVD=0 NOVO=1.99e+26 NOVDO=5e+25 CTO=-0.006328 CTL=0 CTLEXP=1 CTW=0.3006 CTLW=-0.01196 CTGO=0 CTBO=0 STCTO=1 CFL=0.00045884 CFLEXP=2.2055 CFW=0.45909 CFBO=1 CFDO=0 PSCEL=0 PSCELEXP=2 PSCEW=0 PSCEBO=0 PSCEDO=0 UO=0.018428 FBET1=0.15952 FBET1W=-2.1872 LP1=9.9822e-08 LP1W=-1.0871 FBET2=-2.7066 LP2=5.8401e-08 BETW1=-0.097534 BETW2=0.022314 WBET=7.9844e-10 STBETO=1.6489 STBETL=0.029528 STBETW=0.037078 STBETLW=0.046991 MUEO=1.7444601 MUEW=-0.06367 STMUEO=1.0816 THEMUO=1.0324 STTHEMUO=0.26337 CSO=0.18648 CSL=0.21903 CSLEXP=2.0917 CSW=0.0072837 CSLW=0.02 STCSO=2 THECSO=2 STTHECSO=0 XCORO=0.001363 XCORL=8 XCORW=0.0060537 XCORLW=0.058951 STXCORO=-6.939e-18 FETAO=1.2853 RSW1=1970 RSW2=-0.057547 STRSO=-0.24812 RSBO=0.074639 RSGO=0.23490984 THESATO=8.4917e-05 THESATL=0.0067396 THESATLEXP=2.395 THESATW=1.1549 THESATLW=-0.01 STTHESATO=3.0405 STTHESATL=-0.16001 STTHESATW=-0.96988 STTHESATLW=0.36213 THESATBO=0.1 THESATGO=0.6304 AXO=16.822 AXL=3.0092 ALPL=0.0058454 ALPLEXP=0.47562 ALPW=-0.065973 ALP1L1=4.4409e-16 ALP1LEXP=1.347 ALP1L2=1 ALP1W=2 ALP2L1=3.6779e-06 ALP2LEXP=0.2531 ALP2L2=2.2204e-15 ALP2W=0.9582 VPO=1.8436e-06 A1O=47.788 A1L=0.029145 A1W=0.01435 A2O=38.581 STA2O=-0.0049931 A3O=1.1753 A3L=-0.069795 A3W=0.0032538 A4O=0.12593 A4L=-0.07 A4W=-0.04811 GCOO=0 IGINVLW=0 IGOVW=0 IGOVDW=0 STIGO=2 GC2O=0.375 GC3O=0.063 CHIBO=3.1 AGIDLW=6e-10 AGIDLDW=0 BGIDLO=5.5970304 BGIDLDO=41 STBGIDLO=-0.0049461 STBGIDLDO=0 CGIDLO=0.23693 CGIDLDO=0 CGBOVL=-4.669e-16 CFRDW=0 FNTO=1 FNTEXCL=0 NFALW=1.3e+25 NFBLW=5289000000 NFCLW=2e-07 EFO=1.152 LINTNOI=2.5e-08 ALPNOI=2 WEDGE=1e-08 WEDGEW=0 VFBEDGEO=-1 STVFBEDGEO=0.0005 STVFBEDGEL=0 STVFBEDGEW=0 STVFBEDGELW=0 DPHIBEDGEO=0 DPHIBEDGEL=0 DPHIBEDGELEXP=1 DPHIBEDGEW=0 DPHIBEDGELW=0 NSUBEDGEO=5e+23 NSUBEDGEL=0 NSUBEDGELEXP=1 NSUBEDGEW=0 NSUBEDGELW=0 CTEDGEO=0 CTEDGEL=0 CTEDGELEXP=1 FBETEDGE=0 LPEDGE=1e-08 BETEDGEW=0 STBETEDGEO=1 STBETEDGEL=0 STBETEDGEW=0 STBETEDGELW=0 PSCEEDGEL=0 PSCEEDGELEXP=2 PSCEEDGEW=0 PSCEBEDGEO=0 PSCEDEDGEO=0 CFEDGEL=0 CFEDGELEXP=2 CFEDGEW=0 CFDEDGEO=0 CFBEDGEO=0 FNTEDGEO=1 NFAEDGELW=8e+22 NFBEDGELW=30000000 NFCEDGELW=0 EFEDGEO=1 SAREF=1e-06 SBREF=1e-06 WLOD=0 KUO=0 KVSAT=0 TKUO=0 LKUO=0 WKUO=0 PKUO=0 LLODKUO=0 WLODKUO=0 KVTHO=0 LKVTHO=0 WKVTHO=0 PKVTHO=0 LLODVTH=0 WLODVTH=0 STETAO=0 LODETAO=1 SCREF=1e-06 WEB=0 WEC=0 KVTHOWEO=0 KVTHOWEL=0 KVTHOWEW=0 KVTHOWELW=0 KUOWEO=0 KUOWEL=0 KUOWEW=0 KUOWELW=0 TRJ=21 SWJUNEXP=0 IMAX=0.0024527 FREV=1000 CJORBOT=0.0008095 CJORSTI=4.2583e-11 CJORGAT=3.1e-11 VBIRBOT=0.72606 VBIRSTI=0.69819 VBIRGAT=1.199 PBOT=0.33078 PSTI=0.22409 PGAT=0.4474 CJORBOTD=0.001 CJORSTID=1e-09 CJORGATD=1e-09 VBIRBOTD=1 VBIRSTID=1 VBIRGATD=1 PBOTD=0.5 PSTID=0.5 PGATD=0.5 PHIGBOT=1.0641 PHIGSTI=1.3946 PHIGGAT=1.83 IDSATRBOT=3.0606e-08 IDSATRSTI=3.6127e-15 IDSATRGAT=0 CSRHBOT=100 CSRHSTI=0.0001 CSRHGAT=0.0001 XJUNSTI=4.93e-08 XJUNGAT=7.062e-07 PHIGBOTD=1.16 PHIGSTID=1.16 PHIGGATD=1.16 IDSATRBOTD=1e-12 IDSATRSTID=1e-18 IDSATRGATD=1e-18 CSRHBOTD=100 CSRHSTID=0.0001 CSRHGATD=0.0001 XJUNSTID=1e-07 XJUNGATD=1e-07 CTATBOT=100 CTATSTI=0.0001 CTATGAT=0.0001 MEFFTATBOT=0.25 MEFFTATSTI=0.25 MEFFTATGAT=0.25 CTATBOTD=100 CTATSTID=0.0001 CTATGATD=0.0001 MEFFTATBOTD=0.25 MEFFTATSTID=0.25 MEFFTATGATD=0.25 CBBTBOT=1e-12 CBBTSTI=1e-21 CBBTGAT=1e-18 FBBTRBOT=1000000000 FBBTRSTI=1000000000 FBBTRGAT=1000000000 STFBBTBOT=-0.001 STFBBTSTI=-0.001 STFBBTGAT=-0.001 CBBTBOTD=1e-12 CBBTSTID=1e-18 CBBTGATD=1e-18 FBBTRBOTD=1000000000 FBBTRSTID=1000000000 FBBTRGATD=1000000000 STFBBTBOTD=-0.001 STFBBTSTID=-0.001 STFBBTGATD=-0.001 VBRBOT=10 VBRSTI=10 VBRGAT=10 PBRBOT=4 PBRSTI=4 PBRGAT=4 VBRBOTD=10 VBRSTID=10 VBRGATD=10 PBRBOTD=4 PBRSTID=4 PBRGATD=4 VJUNREF=2.5 FJUNQ=0.03 VJUNREFD=2.5 FJUNQD=0.03 RINT=0 RVPOLY=0 DLSIL=0 RSH=0 RSHD=0 CFRW=0 RSHG=40 RGO=15 RBULKO=250 RWELLO=125 RJUNSO=1250 RJUNDO=1250 SWSOA=0 VGS_MAX=3 VGD_MAX=3 VGB_MAX=3 VDS_MAX=3 VDB_MAX=1.6 VSB_MAX=1.6
model hvp_w8000n_l400n_ng1 PSP103VA TYPE=-1 TR=27 DTA=0 SWGEO=1 SWIGATE=1 SWIMPACT=1 SWGIDL=1 SWJUNCAP=3 SWJUNASYM=0 SWNUD=0 SWEDGE=0 SWDELVTAC=0 SWIGN=1 QMC=1 LVARO=-1.735e-09 LVARL=0 LVARW=0 LAP=3.471e-08 WVARO=0 WVARL=0 WVARW=0 WOT=0 DLQ=3.537e-08 DWQ=3e-08 VFBO=-1.0717 VFBL=-0.03 VFBW=0 VFBLW=0 STVFBO=0.00057379 STVFBL=8.6794e-05 STVFBW=4.9309e-05 STVFBLW=-3.6436e-05 ST2VFBO=0 TOXO=6.945e-09 EPSROXO=3.9 NSUBO=4.2268e+23 NSUBW=0.01112 WSEG=5.362e-08 NPCK=8.0711e+23 NPCKW=-0.011403 WSEGP=1e-06 LPCK=8.3733e-09 LPCKW=0.077499 FOL1=0.065253 FOL2=0.010199 FACNEFFACO=1 FACNEFFACL=0 FACNEFFACW=0 FACNEFFACLW=0 GFACNUDO=1 GFACNUDL=0 GFACNUDLEXP=1 GFACNUDW=0 GFACNUDLW=0 VSBNUDO=0 DVSBNUDO=1 VNSUBO=0 NSLPO=0.05 DNSUBO=0.03585 DPHIBO=-0.077884807 DPHIBL=0.00526388544 DPHIBLEXP=2.1893 DPHIBW=-0.011141504 DPHIBLW=-9.3915789e-05 DELVTACO=0 DELVTACL=0 DELVTACLEXP=1 DELVTACW=0 DELVTACLW=0 NPO=1.092e+26 NPL=0.2188 TOXOVO=6.945e-09 TOXOVDO=2e-09 LOV=3.471e-08 LOVD=0 NOVO=1.99e+26 NOVDO=5e+25 CTO=-0.006328 CTL=0 CTLEXP=1 CTW=0.3006 CTLW=-0.01196 CTGO=0 CTBO=0 STCTO=1 CFL=0.00045884 CFLEXP=2.2055 CFW=0.45909 CFBO=1 CFDO=0 PSCEL=0 PSCELEXP=2 PSCEW=0 PSCEBO=0 PSCEDO=0 UO=0.018428 FBET1=0.15952 FBET1W=-2.1872 LP1=9.9822e-08 LP1W=-1.0871 FBET2=-2.7066 LP2=5.8401e-08 BETW1=-0.097534 BETW2=0.022314 WBET=7.9844e-10 STBETO=1.6489 STBETL=0.029528 STBETW=0.037078 STBETLW=0.046991 MUEO=1.7444601 MUEW=-0.06367 STMUEO=1.0816 THEMUO=1.0324 STTHEMUO=0.26337 CSO=0.18648 CSL=0.21903 CSLEXP=2.0917 CSW=0.0072837 CSLW=0.02 STCSO=2 THECSO=2 STTHECSO=0 XCORO=0.001363 XCORL=8 XCORW=0.0060537 XCORLW=0.058951 STXCORO=-6.939e-18 FETAO=1.2853 RSW1=1970 RSW2=-0.057547 STRSO=-0.24812 RSBO=0.074639 RSGO=0.23490984 THESATO=8.4917e-05 THESATL=0.0067396 THESATLEXP=2.395 THESATW=1.1549 THESATLW=-0.01 STTHESATO=3.0405 STTHESATL=-0.16001 STTHESATW=-0.96988 STTHESATLW=0.36213 THESATBO=0.1 THESATGO=0.6304 AXO=16.822 AXL=3.0092 ALPL=0.0058454 ALPLEXP=0.47562 ALPW=-0.065973 ALP1L1=4.4409e-16 ALP1LEXP=1.347 ALP1L2=1 ALP1W=2 ALP2L1=3.6779e-06 ALP2LEXP=0.2531 ALP2L2=2.2204e-15 ALP2W=0.9582 VPO=1.8436e-06 A1O=47.788 A1L=0.029145 A1W=0.01435 A2O=38.581 STA2O=-0.0049931 A3O=1.1753 A3L=-0.069795 A3W=0.0032538 A4O=0.12593 A4L=-0.07 A4W=-0.04811 GCOO=0 IGINVLW=0 IGOVW=0 IGOVDW=0 STIGO=2 GC2O=0.375 GC3O=0.063 CHIBO=3.1 AGIDLW=6e-10 AGIDLDW=0 BGIDLO=5.5970304 BGIDLDO=41 STBGIDLO=-0.0049461 STBGIDLDO=0 CGIDLO=0.23693 CGIDLDO=0 CGBOVL=-4.669e-16 CFRDW=0 FNTO=1 FNTEXCL=0 NFALW=1.3e+25 NFBLW=5289000000 NFCLW=2e-07 EFO=1.152 LINTNOI=2.5e-08 ALPNOI=2 WEDGE=1e-08 WEDGEW=0 VFBEDGEO=-1 STVFBEDGEO=0.0005 STVFBEDGEL=0 STVFBEDGEW=0 STVFBEDGELW=0 DPHIBEDGEO=0 DPHIBEDGEL=0 DPHIBEDGELEXP=1 DPHIBEDGEW=0 DPHIBEDGELW=0 NSUBEDGEO=5e+23 NSUBEDGEL=0 NSUBEDGELEXP=1 NSUBEDGEW=0 NSUBEDGELW=0 CTEDGEO=0 CTEDGEL=0 CTEDGELEXP=1 FBETEDGE=0 LPEDGE=1e-08 BETEDGEW=0 STBETEDGEO=1 STBETEDGEL=0 STBETEDGEW=0 STBETEDGELW=0 PSCEEDGEL=0 PSCEEDGELEXP=2 PSCEEDGEW=0 PSCEBEDGEO=0 PSCEDEDGEO=0 CFEDGEL=0 CFEDGELEXP=2 CFEDGEW=0 CFDEDGEO=0 CFBEDGEO=0 FNTEDGEO=1 NFAEDGELW=8e+22 NFBEDGELW=30000000 NFCEDGELW=0 EFEDGEO=1 SAREF=1e-06 SBREF=1e-06 WLOD=0 KUO=0 KVSAT=0 TKUO=0 LKUO=0 WKUO=0 PKUO=0 LLODKUO=0 WLODKUO=0 KVTHO=0 LKVTHO=0 WKVTHO=0 PKVTHO=0 LLODVTH=0 WLODVTH=0 STETAO=0 LODETAO=1 SCREF=1e-06 WEB=0 WEC=0 KVTHOWEO=0 KVTHOWEL=0 KVTHOWEW=0 KVTHOWELW=0 KUOWEO=0 KUOWEL=0 KUOWEW=0 KUOWELW=0 TRJ=21 SWJUNEXP=0 IMAX=0.0024527 FREV=1000 CJORBOT=0.0008095 CJORSTI=4.2583e-11 CJORGAT=3.1e-11 VBIRBOT=0.72606 VBIRSTI=0.69819 VBIRGAT=1.199 PBOT=0.33078 PSTI=0.22409 PGAT=0.4474 CJORBOTD=0.001 CJORSTID=1e-09 CJORGATD=1e-09 VBIRBOTD=1 VBIRSTID=1 VBIRGATD=1 PBOTD=0.5 PSTID=0.5 PGATD=0.5 PHIGBOT=1.0641 PHIGSTI=1.3946 PHIGGAT=1.83 IDSATRBOT=3.0606e-08 IDSATRSTI=3.6127e-15 IDSATRGAT=0 CSRHBOT=100 CSRHSTI=0.0001 CSRHGAT=0.0001 XJUNSTI=4.93e-08 XJUNGAT=7.062e-07 PHIGBOTD=1.16 PHIGSTID=1.16 PHIGGATD=1.16 IDSATRBOTD=1e-12 IDSATRSTID=1e-18 IDSATRGATD=1e-18 CSRHBOTD=100 CSRHSTID=0.0001 CSRHGATD=0.0001 XJUNSTID=1e-07 XJUNGATD=1e-07 CTATBOT=100 CTATSTI=0.0001 CTATGAT=0.0001 MEFFTATBOT=0.25 MEFFTATSTI=0.25 MEFFTATGAT=0.25 CTATBOTD=100 CTATSTID=0.0001 CTATGATD=0.0001 MEFFTATBOTD=0.25 MEFFTATSTID=0.25 MEFFTATGATD=0.25 CBBTBOT=1e-12 CBBTSTI=1e-21 CBBTGAT=1e-18 FBBTRBOT=1000000000 FBBTRSTI=1000000000 FBBTRGAT=1000000000 STFBBTBOT=-0.001 STFBBTSTI=-0.001 STFBBTGAT=-0.001 CBBTBOTD=1e-12 CBBTSTID=1e-18 CBBTGATD=1e-18 FBBTRBOTD=1000000000 FBBTRSTID=1000000000 FBBTRGATD=1000000000 STFBBTBOTD=-0.001 STFBBTSTID=-0.001 STFBBTGATD=-0.001 VBRBOT=10 VBRSTI=10 VBRGAT=10 PBRBOT=4 PBRSTI=4 PBRGAT=4 VBRBOTD=10 VBRSTID=10 VBRGATD=10 PBRBOTD=4 PBRSTID=4 PBRGATD=4 VJUNREF=2.5 FJUNQ=0.03 VJUNREFD=2.5 FJUNQD=0.03 RINT=0 RVPOLY=0 DLSIL=0 RSH=0 RSHD=0 CFRW=0 RSHG=40 RGO=15 RBULKO=250 RWELLO=125 RJUNSO=250 RJUNDO=250 SWSOA=0 VGS_MAX=3 VGD_MAX=3 VGB_MAX=3 VDS_MAX=3 VDB_MAX=1.6 VSB_MAX=1.6
subckt syn_p0_n0 (vp vn sl wl)
XGp (vp cp) rram level=0
XAp (cp wl sl 0) hvn_w10000n_l450n_ng1 W=1e-05 L=4.5e-07 NF=1 MULT=1 AS=3.4e-12 AD=3.4e-12 PS=2.068e-05 PD=2.068e-05 NGCON=2 DELVTO=0 FACTUO=1
XGn (vn cn) rram level=0
XAn (cn wl sl 0) hvn_w10000n_l450n_ng1 W=1e-05 L=4.5e-07 NF=1 MULT=1 AS=3.4e-12 AD=3.4e-12 PS=2.068e-05 PD=2.068e-05 NGCON=2 DELVTO=0 FACTUO=1
ends syn_p0_n0
subckt syn_p0_n1 (vp vn sl wl)
XGp (vp cp) rram level=0
XAp (cp wl sl 0) hvn_w10000n_l450n_ng1 W=1e-05 L=4.5e-07 NF=1 MULT=1 AS=3.4e-12 AD=3.4e-12 PS=2.068e-05 PD=2.068e-05 NGCON=2 DELVTO=0 FACTUO=1
XGn (vn cn) rram level=1
XAn (cn wl sl 0) hvn_w10000n_l450n_ng1 W=1e-05 L=4.5e-07 NF=1 MULT=1 AS=3.4e-12 AD=3.4e-12 PS=2.068e-05 PD=2.068e-05 NGCON=2 DELVTO=0 FACTUO=1
ends syn_p0_n1
subckt syn_p0_n2 (vp vn sl wl)
XGp (vp cp) rram level=0
XAp (cp wl sl 0) hvn_w10000n_l450n_ng1 W=1e-05 L=4.5e-07 NF=1 MULT=1 AS=3.4e-12 AD=3.4e-12 PS=2.068e-05 PD=2.068e-05 NGCON=2 DELVTO=0 FACTUO=1
XGn (vn cn) rram level=2
XAn (cn wl sl 0) hvn_w10000n_l450n_ng1 W=1e-05 L=4.5e-07 NF=1 MULT=1 AS=3.4e-12 AD=3.4e-12 PS=2.068e-05 PD=2.068e-05 NGCON=2 DELVTO=0 FACTUO=1
ends syn_p0_n2
subckt syn_p0_n3 (vp vn sl wl)
XGp (vp cp) rram level=0
XAp (cp wl sl 0) hvn_w10000n_l450n_ng1 W=1e-05 L=4.5e-07 NF=1 MULT=1 AS=3.4e-12 AD=3.4e-12 PS=2.068e-05 PD=2.068e-05 NGCON=2 DELVTO=0 FACTUO=1
XGn (vn cn) rram level=3
XAn (cn wl sl 0) hvn_w10000n_l450n_ng1 W=1e-05 L=4.5e-07 NF=1 MULT=1 AS=3.4e-12 AD=3.4e-12 PS=2.068e-05 PD=2.068e-05 NGCON=2 DELVTO=0 FACTUO=1
ends syn_p0_n3
subckt syn_p1_n0 (vp vn sl wl)
XGp (vp cp) rram level=1
XAp (cp wl sl 0) hvn_w10000n_l450n_ng1 W=1e-05 L=4.5e-07 NF=1 MULT=1 AS=3.4e-12 AD=3.4e-12 PS=2.068e-05 PD=2.068e-05 NGCON=2 DELVTO=0 FACTUO=1
XGn (vn cn) rram level=0
XAn (cn wl sl 0) hvn_w10000n_l450n_ng1 W=1e-05 L=4.5e-07 NF=1 MULT=1 AS=3.4e-12 AD=3.4e-12 PS=2.068e-05 PD=2.068e-05 NGCON=2 DELVTO=0 FACTUO=1
ends syn_p1_n0
subckt syn_p1_n1 (vp vn sl wl)
XGp (vp cp) rram level=1
XAp (cp wl sl 0) hvn_w10000n_l450n_ng1 W=1e-05 L=4.5e-07 NF=1 MULT=1 AS=3.4e-12 AD=3.4e-12 PS=2.068e-05 PD=2.068e-05 NGCON=2 DELVTO=0 FACTUO=1
XGn (vn cn) rram level=1
XAn (cn wl sl 0) hvn_w10000n_l450n_ng1 W=1e-05 L=4.5e-07 NF=1 MULT=1 AS=3.4e-12 AD=3.4e-12 PS=2.068e-05 PD=2.068e-05 NGCON=2 DELVTO=0 FACTUO=1
ends syn_p1_n1
subckt syn_p1_n2 (vp vn sl wl)
XGp (vp cp) rram level=1
XAp (cp wl sl 0) hvn_w10000n_l450n_ng1 W=1e-05 L=4.5e-07 NF=1 MULT=1 AS=3.4e-12 AD=3.4e-12 PS=2.068e-05 PD=2.068e-05 NGCON=2 DELVTO=0 FACTUO=1
XGn (vn cn) rram level=2
XAn (cn wl sl 0) hvn_w10000n_l450n_ng1 W=1e-05 L=4.5e-07 NF=1 MULT=1 AS=3.4e-12 AD=3.4e-12 PS=2.068e-05 PD=2.068e-05 NGCON=2 DELVTO=0 FACTUO=1
ends syn_p1_n2
subckt syn_p1_n3 (vp vn sl wl)
XGp (vp cp) rram level=1
XAp (cp wl sl 0) hvn_w10000n_l450n_ng1 W=1e-05 L=4.5e-07 NF=1 MULT=1 AS=3.4e-12 AD=3.4e-12 PS=2.068e-05 PD=2.068e-05 NGCON=2 DELVTO=0 FACTUO=1
XGn (vn cn) rram level=3
XAn (cn wl sl 0) hvn_w10000n_l450n_ng1 W=1e-05 L=4.5e-07 NF=1 MULT=1 AS=3.4e-12 AD=3.4e-12 PS=2.068e-05 PD=2.068e-05 NGCON=2 DELVTO=0 FACTUO=1
ends syn_p1_n3
subckt syn_p2_n0 (vp vn sl wl)
XGp (vp cp) rram level=2
XAp (cp wl sl 0) hvn_w10000n_l450n_ng1 W=1e-05 L=4.5e-07 NF=1 MULT=1 AS=3.4e-12 AD=3.4e-12 PS=2.068e-05 PD=2.068e-05 NGCON=2 DELVTO=0 FACTUO=1
XGn (vn cn) rram level=0
XAn (cn wl sl 0) hvn_w10000n_l450n_ng1 W=1e-05 L=4.5e-07 NF=1 MULT=1 AS=3.4e-12 AD=3.4e-12 PS=2.068e-05 PD=2.068e-05 NGCON=2 DELVTO=0 FACTUO=1
ends syn_p2_n0
subckt syn_p2_n1 (vp vn sl wl)
XGp (vp cp) rram level=2
XAp (cp wl sl 0) hvn_w10000n_l450n_ng1 W=1e-05 L=4.5e-07 NF=1 MULT=1 AS=3.4e-12 AD=3.4e-12 PS=2.068e-05 PD=2.068e-05 NGCON=2 DELVTO=0 FACTUO=1
XGn (vn cn) rram level=1
XAn (cn wl sl 0) hvn_w10000n_l450n_ng1 W=1e-05 L=4.5e-07 NF=1 MULT=1 AS=3.4e-12 AD=3.4e-12 PS=2.068e-05 PD=2.068e-05 NGCON=2 DELVTO=0 FACTUO=1
ends syn_p2_n1
subckt syn_p2_n2 (vp vn sl wl)
XGp (vp cp) rram level=2
XAp (cp wl sl 0) hvn_w10000n_l450n_ng1 W=1e-05 L=4.5e-07 NF=1 MULT=1 AS=3.4e-12 AD=3.4e-12 PS=2.068e-05 PD=2.068e-05 NGCON=2 DELVTO=0 FACTUO=1
XGn (vn cn) rram level=2
XAn (cn wl sl 0) hvn_w10000n_l450n_ng1 W=1e-05 L=4.5e-07 NF=1 MULT=1 AS=3.4e-12 AD=3.4e-12 PS=2.068e-05 PD=2.068e-05 NGCON=2 DELVTO=0 FACTUO=1
ends syn_p2_n2
subckt syn_p2_n3 (vp vn sl wl)
XGp (vp cp) rram level=2
XAp (cp wl sl 0) hvn_w10000n_l450n_ng1 W=1e-05 L=4.5e-07 NF=1 MULT=1 AS=3.4e-12 AD=3.4e-12 PS=2.068e-05 PD=2.068e-05 NGCON=2 DELVTO=0 FACTUO=1
XGn (vn cn) rram level=3
XAn (cn wl sl 0) hvn_w10000n_l450n_ng1 W=1e-05 L=4.5e-07 NF=1 MULT=1 AS=3.4e-12 AD=3.4e-12 PS=2.068e-05 PD=2.068e-05 NGCON=2 DELVTO=0 FACTUO=1
ends syn_p2_n3
subckt syn_p3_n0 (vp vn sl wl)
XGp (vp cp) rram level=3
XAp (cp wl sl 0) hvn_w10000n_l450n_ng1 W=1e-05 L=4.5e-07 NF=1 MULT=1 AS=3.4e-12 AD=3.4e-12 PS=2.068e-05 PD=2.068e-05 NGCON=2 DELVTO=0 FACTUO=1
XGn (vn cn) rram level=0
XAn (cn wl sl 0) hvn_w10000n_l450n_ng1 W=1e-05 L=4.5e-07 NF=1 MULT=1 AS=3.4e-12 AD=3.4e-12 PS=2.068e-05 PD=2.068e-05 NGCON=2 DELVTO=0 FACTUO=1
ends syn_p3_n0
subckt syn_p3_n1 (vp vn sl wl)
XGp (vp cp) rram level=3
XAp (cp wl sl 0) hvn_w10000n_l450n_ng1 W=1e-05 L=4.5e-07 NF=1 MULT=1 AS=3.4e-12 AD=3.4e-12 PS=2.068e-05 PD=2.068e-05 NGCON=2 DELVTO=0 FACTUO=1
XGn (vn cn) rram level=1
XAn (cn wl sl 0) hvn_w10000n_l450n_ng1 W=1e-05 L=4.5e-07 NF=1 MULT=1 AS=3.4e-12 AD=3.4e-12 PS=2.068e-05 PD=2.068e-05 NGCON=2 DELVTO=0 FACTUO=1
ends syn_p3_n1
subckt syn_p3_n2 (vp vn sl wl)
XGp (vp cp) rram level=3
XAp (cp wl sl 0) hvn_w10000n_l450n_ng1 W=1e-05 L=4.5e-07 NF=1 MULT=1 AS=3.4e-12 AD=3.4e-12 PS=2.068e-05 PD=2.068e-05 NGCON=2 DELVTO=0 FACTUO=1
XGn (vn cn) rram level=2
XAn (cn wl sl 0) hvn_w10000n_l450n_ng1 W=1e-05 L=4.5e-07 NF=1 MULT=1 AS=3.4e-12 AD=3.4e-12 PS=2.068e-05 PD=2.068e-05 NGCON=2 DELVTO=0 FACTUO=1
ends syn_p3_n2
subckt syn_p3_n3 (vp vn sl wl)
XGp (vp cp) rram level=3
XAp (cp wl sl 0) hvn_w10000n_l450n_ng1 W=1e-05 L=4.5e-07 NF=1 MULT=1 AS=3.4e-12 AD=3.4e-12 PS=2.068e-05 PD=2.068e-05 NGCON=2 DELVTO=0 FACTUO=1
XGn (vn cn) rram level=3
XAn (cn wl sl 0) hvn_w10000n_l450n_ng1 W=1e-05 L=4.5e-07 NF=1 MULT=1 AS=3.4e-12 AD=3.4e-12 PS=2.068e-05 PD=2.068e-05 NGCON=2 DELVTO=0 FACTUO=1
ends syn_p3_n3
subckt dff (d q m clk qclk)
XSm (d mc clk) vswitch vt=2.5
Cm (mc 0) capacitor c=1e-14 ic=0
Em (m 0 mc 0) vcvs gain=1
XSs (m s qclk) vswitch
Cs (s 0) capacitor c=1e-14 ic=0
Eq (q 0 s 0) vcvs gain=1
ends dff
subckt neuron_h2 (sl spk clk qclk vref vres vth)
Xin (sl vref vm clk) sl_stage k=1.06165769
CM (vm 0) capacitor c=9.98e-13 ic=0
XSlk (vm cl qclk) vswitch
CL (cl 0) capacitor c=6.6e-13 ic=0
XSdis (cl 0 clk) vswitch
Xcmp (vm vth cmp) comparator
Xff0 (cmp q0 m0 clk qclk) dff
Espk (spk 0 q0 0) vcvs gain=1
Xlog (q0 0 0 0 0 m0 0 clk 0 rs hz) neuron_logic refr=0
XSrst (vm vres rs) vswitch
ends neuron_h2
subckt neuron_h3 (sl spk clk qclk vref vres vth)
Xin (sl vref vm clk) sl_stage k=1.10472234
CM (vm 0) capacitor c=9.98e-13 ic=0
XSlk (vm cl qclk) vswitch
CL (cl 0) capacitor c=6.6e-13 ic=0
XSdis (cl 0 clk) vswitch
Xcmp (vm vth cmp) comparator
Xff0 (cmp q0 m0 clk qclk) dff
Espk (spk 0 q0 0) vcvs gain=1
Xlog (q0 0 0 0 0 m0 0 clk 0 rs hz) neuron_logic refr=0
XSrst (vm vres rs) vswitch
ends neuron_h3
subckt neuron_out (sl spk clk qclk vref vres vth)
Xin (sl vref vm clk) sl_stage k=1.16226136
CM (vm 0) capacitor c=9.98e-13 ic=0
XSlk (vm cl qclk) vswitch
CL (cl 0) capacitor c=6.6e-13 ic=0
XSdis (cl 0 clk) vswitch
Xcmp (vm vth cmp) comparator
Xff0 (cmp q0 m0 clk qclk) dff
Espk (spk 0 q0 0) vcvs gain=1
Xlog (q0 0 0 0 0 m0 0 clk 0 rs hz) neuron_logic refr=0
XSrst (vm vres rs) vswitch
ends neuron_out
Vvp (vp 0) vsource dc=0 type=pwl wave=[ \
    0 0 1e-09 1.75 ]
Vvn (vn 0) vsource dc=0 type=pwl wave=[ \
    0 0 1e-09 1.55 ]
Vref (vref 0) vsource dc=0 type=pwl wave=[ \
    0 0 1e-09 1.65 ]
Vres (vres 0) vsource dc=0 type=pwl wave=[ \
    0 0 1e-09 1 ]
Vth (vth 0) vsource dc=0 type=pwl wave=[ \
    0 0 1e-09 2.4 ]
Vclk (clk 0) vsource dc=0 type=pulse val0=0 val1=3.3 delay=1.245e-07 rise=1e-09 fall=1e-09 width=1.24e-07 period=2.5e-07
Vqclk (qclk 0) vsource dc=0 type=pulse val0=0 val1=3.3 delay=2e-09 rise=1e-09 fall=1e-09 width=1.19e-07 period=2.5e-07
Vqclkb (qclkb 0) vsource dc=0 type=pulse val0=0 val1=3.3 delay=1.22e-07 rise=1e-09 fall=1e-09 width=1.29e-07 period=2.5e-07
Vclkb (clkb 0) vsource dc=0 type=pwl wave=[ \
    0 0 1e-09 3.3 1.245e-07 3.3 1.255e-07 0 2.495e-07 0 2.505e-07 3.3 \
    3.745e-07 3.3 3.755e-07 0 4.995e-07 0 5.005e-07 3.3 ]
Vdd (vdd 0) vsource dc=0 type=pwl wave=[ \
    0 0 1e-09 3.3 ]
Vbn (vbn 0) vsource dc=0 type=pwl wave=[ \
    0 0 1e-09 0.8 ]
Vvbp (vbp 0) vsource dc=0 type=pwl wave=[ \
    0 0 1e-09 1.8 ]
Vvbpc (vbpc 0) vsource dc=0 type=pwl wave=[ \
    0 0 1e-09 1.7 ]
Vvbnc (vbnc 0) vsource dc=0 type=pwl wave=[ \
    0 0 1e-09 1.2 ]
Vvbs (vbs 0) vsource dc=0 type=pwl wave=[ \
    0 0 1e-09 0.8703 ]
Vh1_0 (h1_0 0) vsource dc=0 type=pwl wave=[ \
    0 0 ]
Vh1_1 (h1_1 0) vsource dc=0 type=pwl wave=[ \
    0 0 5e-07 0 5.01e-07 3.3 7.5e-07 3.3 7.51e-07 0 1e-06 0 \
    1.001e-06 3.3 1.25e-06 3.3 1.251e-06 0 1.5e-06 0 1.501e-06 3.3 1.75e-06 3.3 \
    1.751e-06 0 2e-06 0 2.001e-06 3.3 2.25e-06 3.3 2.251e-06 0 2.5e-06 0 \
    2.501e-06 3.3 2.75e-06 3.3 2.751e-06 0 3e-06 0 3.001e-06 3.3 3.25e-06 3.3 \
    3.251e-06 0 3.5e-06 0 3.501e-06 3.3 3.75e-06 3.3 3.751e-06 0 4e-06 0 \
    4.001e-06 3.3 4.25e-06 3.3 4.251e-06 0 4.5e-06 0 4.501e-06 3.3 4.75e-06 3.3 \
    4.751e-06 0 5e-06 0 5.001e-06 3.3 5.25e-06 3.3 5.251e-06 0 5.5e-06 0 \
    5.501e-06 3.3 5.75e-06 3.3 5.751e-06 0 6e-06 0 6.001e-06 3.3 6.25e-06 3.3 \
    6.251e-06 0 ]
Vh1_2 (h1_2 0) vsource dc=0 type=pwl wave=[ \
    0 0 ]
Vh1_3 (h1_3 0) vsource dc=0 type=pwl wave=[ \
    0 0 ]
Vh1_4 (h1_4 0) vsource dc=0 type=pwl wave=[ \
    0 0 ]
Vh1_5 (h1_5 0) vsource dc=0 type=pwl wave=[ \
    0 0 ]
Vh1_6 (h1_6 0) vsource dc=0 type=pwl wave=[ \
    0 0 ]
Vh1_7 (h1_7 0) vsource dc=0 type=pwl wave=[ \
    0 0 7.5e-07 0 7.51e-07 3.3 1e-06 3.3 1.001e-06 0 1.5e-06 0 \
    1.501e-06 3.3 1.75e-06 3.3 1.751e-06 0 2.25e-06 0 2.251e-06 3.3 2.5e-06 3.3 \
    2.501e-06 0 3e-06 0 3.001e-06 3.3 3.25e-06 3.3 3.251e-06 0 3.75e-06 0 \
    3.751e-06 3.3 4e-06 3.3 4.001e-06 0 4.5e-06 0 4.501e-06 3.3 4.75e-06 3.3 \
    4.751e-06 0 5.25e-06 0 5.251e-06 3.3 5.5e-06 3.3 5.501e-06 0 6e-06 0 \
    6.001e-06 3.3 6.25e-06 3.3 6.251e-06 0 ]
Vh1_8 (h1_8 0) vsource dc=0 type=pwl wave=[ \
    0 0 ]
Vh1_9 (h1_9 0) vsource dc=0 type=pwl wave=[ \
    0 0 ]
Vh1_10 (h1_10 0) vsource dc=0 type=pwl wave=[ \
    0 0 ]
Vh1_11 (h1_11 0) vsource dc=0 type=pwl wave=[ \
    0 0 ]
Vh1_12 (h1_12 0) vsource dc=0 type=pwl wave=[ \
    0 0 ]
Vh1_13 (h1_13 0) vsource dc=0 type=pwl wave=[ \
    0 0 ]
Vh1_14 (h1_14 0) vsource dc=0 type=pwl wave=[ \
    0 0 ]
Vh1_15 (h1_15 0) vsource dc=0 type=pwl wave=[ \
    0 0 1.25e-06 0 1.251e-06 3.3 1.5e-06 3.3 1.501e-06 0 2.5e-06 0 \
    2.501e-06 3.3 2.75e-06 3.3 2.751e-06 0 3.75e-06 0 3.751e-06 3.3 4e-06 3.3 \
    4.001e-06 0 5e-06 0 5.001e-06 3.3 5.25e-06 3.3 5.251e-06 0 6.25e-06 0 \
    6.251e-06 3.3 6.5e-06 3.3 6.501e-06 0 ]
Vh1_16 (h1_16 0) vsource dc=0 type=pwl wave=[ \
    0 0 ]
Vh1_17 (h1_17 0) vsource dc=0 type=pwl wave=[ \
    0 0 1e-06 0 1.001e-06 3.3 1.25e-06 3.3 1.251e-06 0 2e-06 0 \
    2.001e-06 3.3 2.25e-06 3.3 2.251e-06 0 3e-06 0 3.001e-06 3.3 3.25e-06 3.3 \
    3.251e-06 0 4e-06 0 4.001e-06 3.3 4.25e-06 3.3 4.251e-06 0 5e-06 0 \
    5.001e-06 3.3 5.25e-06 3.3 5.251e-06 0 6e-06 0 6.001e-06 3.3 6.25e-06 3.3 \
    6.251e-06 0 ]
Vh1_18 (h1_18 0) vsource dc=0 type=pwl wave=[ \
    0 0 ]
Vh1_19 (h1_19 0) vsource dc=0 type=pwl wave=[ \
    0 0 ]
Vh1_20 (h1_20 0) vsource dc=0 type=pwl wave=[ \
    0 0 ]
Vh1_21 (h1_21 0) vsource dc=0 type=pwl wave=[ \
    0 0 ]
Vh1_22 (h1_22 0) vsource dc=0 type=pwl wave=[ \
    0 0 ]
Vh1_23 (h1_23 0) vsource dc=0 type=pwl wave=[ \
    0 0 2.5e-07 0 2.51e-07 3.3 5e-07 3.3 5.01e-07 0 7.5e-07 0 \
    7.51e-07 3.3 1e-06 3.3 1.001e-06 0 1.25e-06 0 1.251e-06 3.3 1.5e-06 3.3 \
    1.501e-06 0 1.75e-06 0 1.751e-06 3.3 2e-06 3.3 2.001e-06 0 2.25e-06 0 \
    2.251e-06 3.3 2.5e-06 3.3 2.501e-06 0 2.75e-06 0 2.751e-06 3.3 3e-06 3.3 \
    3.001e-06 0 3.25e-06 0 3.251e-06 3.3 3.5e-06 3.3 3.501e-06 0 3.75e-06 0 \
    3.751e-06 3.3 4e-06 3.3 4.001e-06 0 4.25e-06 0 4.251e-06 3.3 4.5e-06 3.3 \
    4.501e-06 0 4.75e-06 0 4.751e-06 3.3 5e-06 3.3 5.001e-06 0 5.25e-06 0 \
    5.251e-06 3.3 5.5e-06 3.3 5.501e-06 0 5.75e-06 0 5.751e-06 3.3 6e-06 3.3 \
    6.001e-06 0 6.25e-06 0 6.251e-06 3.3 6.5e-06 3.3 6.501e-06 0 ]
Vh1_24 (h1_24 0) vsource dc=0 type=pwl wave=[ \
    0 0 7.5e-07 0 7.51e-07 3.3 1e-06 3.3 1.001e-06 0 1.5e-06 0 \
    1.501e-06 3.3 1.75e-06 3.3 1.751e-06 0 2.25e-06 0 2.251e-06 3.3 2.5e-06 3.3 \
    2.501e-06 0 3e-06 0 3.001e-06 3.3 3.25e-06 3.3 3.251e-06 0 3.75e-06 0 \
    3.751e-06 3.3 4e-06 3.3 4.001e-06 0 4.5e-06 0 4.501e-06 3.3 4.75e-06 3.3 \
    4.751e-06 0 5.25e-06 0 5.251e-06 3.3 5.5e-06 3.3 5.501e-06 0 6e-06 0 \
    6.001e-06 3.3 6.25e-06 3.3 6.251e-06 0 ]
Vh1_25 (h1_25 0) vsource dc=0 type=pwl wave=[ \
    0 0 ]
Vh1_26 (h1_26 0) vsource dc=0 type=pwl wave=[ \
    0 0 ]
Vh1_27 (h1_27 0) vsource dc=0 type=pwl wave=[ \
    0 0 ]
Vh1_28 (h1_28 0) vsource dc=0 type=pwl wave=[ \
    0 0 5e-07 0 5.01e-07 3.3 7.5e-07 3.3 7.51e-07 0 1.25e-06 0 \
    1.251e-06 3.3 1.5e-06 3.3 1.501e-06 0 2e-06 0 2.001e-06 3.3 2.25e-06 3.3 \
    2.251e-06 0 2.75e-06 0 2.751e-06 3.3 3e-06 3.3 3.001e-06 0 3.5e-06 0 \
    3.501e-06 3.3 3.75e-06 3.3 3.751e-06 0 4.25e-06 0 4.251e-06 3.3 4.5e-06 3.3 \
    4.501e-06 0 5e-06 0 5.001e-06 3.3 5.25e-06 3.3 5.251e-06 0 5.75e-06 0 \
    5.751e-06 3.3 6e-06 3.3 6.001e-06 0 ]
Vh1_29 (h1_29 0) vsource dc=0 type=pwl wave=[ \
    0 0 ]
Vh1_30 (h1_30 0) vsource dc=0 type=pwl wave=[ \
    0 0 ]
Vh1_31 (h1_31 0) vsource dc=0 type=pwl wave=[ \
    0 0 ]
Vh1_32 (h1_32 0) vsource dc=0 type=pwl wave=[ \
    0 0 ]
Vh1_33 (h1_33 0) vsource dc=0 type=pwl wave=[ \
    0 0 ]
Vh1_34 (h1_34 0) vsource dc=0 type=pwl wave=[ \
    0 0 ]
Vh1_35 (h1_35 0) vsource dc=0 type=pwl wave=[ \
    0 0 ]
Vh1_36 (h1_36 0) vsource dc=0 type=pwl wave=[ \
    0 0 ]
Vh1_37 (h1_37 0) vsource dc=0 type=pwl wave=[ \
    0 0 ]
Vh1_38 (h1_38 0) vsource dc=0 type=pwl wave=[ \
    0 0 1e-06 0 1.001e-06 3.3 1.25e-06 3.3 1.251e-06 0 2e-06 0 \
    2.001e-06 3.3 2.25e-06 3.3 2.251e-06 0 3e-06 0 3.001e-06 3.3 3.25e-06 3.3 \
    3.251e-06 0 4e-06 0 4.001e-06 3.3 4.25e-06 3.3 4.251e-06 0 5e-06 0 \
    5.001e-06 3.3 5.25e-06 3.3 5.251e-06 0 6e-06 0 6.001e-06 3.3 6.25e-06 3.3 \
    6.251e-06 0 ]
Vh1_39 (h1_39 0) vsource dc=0 type=pwl wave=[ \
    0 0 ]
Vh1_40 (h1_40 0) vsource dc=0 type=pwl wave=[ \
    0 0 ]
Vh1_41 (h1_41 0) vsource dc=0 type=pwl wave=[ \
    0 0 ]
Vh1_42 (h1_42 0) vsource dc=0 type=pwl wave=[ \
    0 0 ]
Vh1_43 (h1_43 0) vsource dc=0 type=pwl wave=[ \
    0 0 ]
Vh1_44 (h1_44 0) vsource dc=0 type=pwl wave=[ \
    0 0 ]
Vh1_45 (h1_45 0) vsource dc=0 type=pwl wave=[ \
    0 0 ]
Vh1_46 (h1_46 0) vsource dc=0 type=pwl wave=[ \
    0 0 5e-07 0 5.01e-07 3.3 7.5e-07 3.3 7.51e-07 0 1e-06 0 \
    1.001e-06 3.3 1.25e-06 3.3 1.251e-06 0 1.5e-06 0 1.501e-06 3.3 1.75e-06 3.3 \
    1.751e-06 0 2e-06 0 2.001e-06 3.3 2.25e-06 3.3 2.251e-06 0 2.5e-06 0 \
    2.501e-06 3.3 2.75e-06 3.3 2.751e-06 0 3e-06 0 3.001e-06 3.3 3.25e-06 3.3 \
    3.251e-06 0 3.5e-06 0 3.501e-06 3.3 3.75e-06 3.3 3.751e-06 0 4e-06 0 \
    4.001e-06 3.3 4.25e-06 3.3 4.251e-06 0 4.5e-06 0 4.501e-06 3.3 4.75e-06 3.3 \
    4.751e-06 0 5e-06 0 5.001e-06 3.3 5.25e-06 3.3 5.251e-06 0 5.5e-06 0 \
    5.501e-06 3.3 5.75e-06 3.3 5.751e-06 0 6e-06 0 6.001e-06 3.3 6.25e-06 3.3 \
    6.251e-06 0 ]
Vh1_47 (h1_47 0) vsource dc=0 type=pwl wave=[ \
    0 0 ]
Vh1_48 (h1_48 0) vsource dc=0 type=pwl wave=[ \
    0 0 ]
Vh1_49 (h1_49 0) vsource dc=0 type=pwl wave=[ \
    0 0 5e-07 0 5.01e-07 3.3 7.5e-07 3.3 7.51e-07 0 1e-06 0 \
    1.001e-06 3.3 1.25e-06 3.3 1.251e-06 0 1.5e-06 0 1.501e-06 3.3 1.75e-06 3.3 \
    1.751e-06 0 2e-06 0 2.001e-06 3.3 2.25e-06 3.3 2.251e-06 0 2.5e-06 0 \
    2.501e-06 3.3 2.75e-06 3.3 2.751e-06 0 3e-06 0 3.001e-06 3.3 3.25e-06 3.3 \
    3.251e-06 0 3.5e-06 0 3.501e-06 3.3 3.75e-06 3.3 3.751e-06 0 4e-06 0 \
    4.001e-06 3.3 4.25e-06 3.3 4.251e-06 0 4.5e-06 0 4.501e-06 3.3 4.75e-06 3.3 \
    4.751e-06 0 5e-06 0 5.001e-06 3.3 5.25e-06 3.3 5.251e-06 0 5.5e-06 0 \
    5.501e-06 3.3 5.75e-06 3.3 5.751e-06 0 6e-06 0 6.001e-06 3.3 6.25e-06 3.3 \
    6.251e-06 0 ]
Vh1_50 (h1_50 0) vsource dc=0 type=pwl wave=[ \
    0 0 7.5e-07 0 7.51e-07 3.3 1e-06 3.3 1.001e-06 0 1.5e-06 0 \
    1.501e-06 3.3 1.75e-06 3.3 1.751e-06 0 2.25e-06 0 2.251e-06 3.3 2.5e-06 3.3 \
    2.501e-06 0 3e-06 0 3.001e-06 3.3 3.25e-06 3.3 3.251e-06 0 3.75e-06 0 \
    3.751e-06 3.3 4e-06 3.3 4.001e-06 0 4.5e-06 0 4.501e-06 3.3 4.75e-06 3.3 \
    4.751e-06 0 5.25e-06 0 5.251e-06 3.3 5.5e-06 3.3 5.501e-06 0 6e-06 0 \
    6.001e-06 3.3 6.25e-06 3.3 6.251e-06 0 ]
Vh1_51 (h1_51 0) vsource dc=0 type=pwl wave=[ \
    0 0 ]
Vh1_52 (h1_52 0) vsource dc=0 type=pwl wave=[ \
    0 0 ]
Vh1_53 (h1_53 0) vsource dc=0 type=pwl wave=[ \
    0 0 ]
Vh1_54 (h1_54 0) vsource dc=0 type=pwl wave=[ \
    0 0 ]
Vh1_55 (h1_55 0) vsource dc=0 type=pwl wave=[ \
    0 0 7.5e-07 0 7.51e-07 3.3 1e-06 3.3 1.001e-06 0 1.75e-06 0 \
    1.751e-06 3.3 2e-06 3.3 2.001e-06 0 2.75e-06 0 2.751e-06 3.3 3e-06 3.3 \
    3.001e-06 0 3.75e-06 0 3.751e-06 3.3 4e-06 3.3 4.001e-06 0 4.75e-06 0 \
    4.751e-06 3.3 5e-06 3.3 5.001e-06 0 5.75e-06 0 5.751e-06 3.3 6e-06 3.3 \
    6.001e-06 0 ]
Vh1_56 (h1_56 0) vsource dc=0 type=pwl wave=[ \
    0 0 ]
Vh1_57 (h1_57 0) vsource dc=0 type=pwl wave=[ \
    0 0 ]
Vh1_58 (h1_58 0) vsource dc=0 type=pwl wave=[ \
    0 0 2.5e-07 0 2.51e-07 3.3 5e-07 3.3 5.01e-07 0 7.5e-07 0 \
    7.51e-07 3.3 1e-06 3.3 1.001e-06 0 1.25e-06 0 1.251e-06 3.3 1.5e-06 3.3 \
    1.501e-06 0 1.75e-06 0 1.751e-06 3.3 2e-06 3.3 2.001e-06 0 2.25e-06 0 \
    2.251e-06 3.3 2.5e-06 3.3 2.501e-06 0 2.75e-06 0 2.751e-06 3.3 3e-06 3.3 \
    3.001e-06 0 3.25e-06 0 3.251e-06 3.3 3.5e-06 3.3 3.501e-06 0 3.75e-06 0 \
    3.751e-06 3.3 4e-06 3.3 4.001e-06 0 4.25e-06 0 4.251e-06 3.3 4.5e-06 3.3 \
    4.501e-06 0 4.75e-06 0 4.751e-06 3.3 5e-06 3.3 5.001e-06 0 5.25e-06 0 \
    5.251e-06 3.3 5.5e-06 3.3 5.501e-06 0 5.75e-06 0 5.751e-06 3.3 6e-06 3.3 \
    6.001e-06 0 6.25e-06 0 6.251e-06 3.3 6.5e-06 3.3 6.501e-06 0 ]
Vh1_59 (h1_59 0) vsource dc=0 type=pwl wave=[ \
    0 0 ]
Vh1_60 (h1_60 0) vsource dc=0 type=pwl wave=[ \
    0 0 ]
Vh1_61 (h1_61 0) vsource dc=0 type=pwl wave=[ \
    0 0 ]
Vh1_62 (h1_62 0) vsource dc=0 type=pwl wave=[ \
    0 0 5e-07 0 5.01e-07 3.3 7.5e-07 3.3 7.51e-07 0 1e-06 0 \
    1.001e-06 3.3 1.25e-06 3.3 1.251e-06 0 1.5e-06 0 1.501e-06 3.3 1.75e-06 3.3 \
    1.751e-06 0 2e-06 0 2.001e-06 3.3 2.25e-06 3.3 2.251e-06 0 2.5e-06 0 \
    2.501e-06 3.3 2.75e-06 3.3 2.751e-06 0 3e-06 0 3.001e-06 3.3 3.25e-06 3.3 \
    3.251e-06 0 3.5e-06 0 3.501e-06 3.3 3.75e-06 3.3 3.751e-06 0 4e-06 0 \
    4.001e-06 3.3 4.25e-06 3.3 4.251e-06 0 4.5e-06 0 4.501e-06 3.3 4.75e-06 3.3 \
    4.751e-06 0 5e-06 0 5.001e-06 3.3 5.25e-06 3.3 5.251e-06 0 5.5e-06 0 \
    5.501e-06 3.3 5.75e-06 3.3 5.751e-06 0 6e-06 0 6.001e-06 3.3 6.25e-06 3.3 \
    6.251e-06 0 ]
Vh1_63 (h1_63 0) vsource dc=0 type=pwl wave=[ \
    0 0 ]
XS_h2_0_0 (vp vn sl_h2_0 h1_0) syn_p0_n1
XS_h2_0_1 (vp vn sl_h2_0 h1_1) syn_p2_n0
XS_h2_0_2 (vp vn sl_h2_0 h1_2) syn_p1_n0
XS_h2_0_3 (vp vn sl_h2_0 h1_3) syn_p0_n1
XS_h2_0_4 (vp vn sl_h2_0 h1_4) syn_p0_n2
XS_h2_0_5 (vp vn sl_h2_0 h1_5) syn_p0_n1
XS_h2_0_6 (vp vn sl_h2_0 h1_6) syn_p1_n0
XS_h2_0_7 (vp vn sl_h2_0 h1_7) syn_p3_n3
XS_h2_0_8 (vp vn sl_h2_0 h1_8) syn_p0_n1
XS_h2_0_9 (vp vn sl_h2_0 h1_9) syn_p0_n2
XS_h2_0_10 (vp vn sl_h2_0 h1_10) syn_p0_n1
XS_h2_0_11 (vp vn sl_h2_0 h1_11) syn_p3_n3
XS_h2_0_12 (vp vn sl_h2_0 h1_12) syn_p3_n1
XS_h2_0_13 (vp vn sl_h2_0 h1_13) syn_p3_n1
XS_h2_0_14 (vp vn sl_h2_0 h1_14) syn_p3_n3
XS_h2_0_15 (vp vn sl_h2_0 h1_15) syn_p3_n3
XS_h2_0_16 (vp vn sl_h2_0 h1_16) syn_p1_n3
XS_h2_0_17 (vp vn sl_h2_0 h1_17) syn_p1_n0
XS_h2_0_18 (vp vn sl_h2_0 h1_18) syn_p0_n1
XS_h2_0_19 (vp vn sl_h2_0 h1_19) syn_p0_n1
XS_h2_0_20 (vp vn sl_h2_0 h1_20) syn_p0_n1
XS_h2_0_21 (vp vn sl_h2_0 h1_21) syn_p0_n1
XS_h2_0_22 (vp vn sl_h2_0 h1_22) syn_p0_n1
XS_h2_0_23 (vp vn sl_h2_0 h1_23) syn_p1_n0
XS_h2_0_24 (vp vn sl_h2_0 h1_24) syn_p0_n2
XS_h2_0_25 (vp vn sl_h2_0 h1_25) syn_p0_n3
XS_h2_0_26 (vp vn sl_h2_0 h1_26) syn_p3_n1
XS_h2_0_27 (vp vn sl_h2_0 h1_27) syn_p0_n2
XS_h2_0_28 (vp vn sl_h2_0 h1_28) syn_p3_n3
XS_h2_0_29 (vp vn sl_h2_0 h1_29) syn_p1_n3
XS_h2_0_30 (vp vn sl_h2_0 h1_30) syn_p0_n1
XS_h2_0_31 (vp vn sl_h2_0 h1_31) syn_p2_n0
XS_h2_0_32 (vp vn sl_h2_0 h1_32) syn_p0_n2
XS_h2_0_33 (vp vn sl_h2_0 h1_33) syn_p3_n1
XS_h2_0_34 (vp vn sl_h2_0 h1_34) syn_p0_n1
XS_h2_0_35 (vp vn sl_h2_0 h1_35) syn_p1_n0
XS_h2_0_36 (vp vn sl_h2_0 h1_36) syn_p3_n3
XS_h2_0_37 (vp vn sl_h2_0 h1_37) syn_p1_n0
XS_h2_0_38 (vp vn sl_h2_0 h1_38) syn_p3_n3
XS_h2_0_39 (vp vn sl_h2_0 h1_39) syn_p3_n3
XS_h2_0_40 (vp vn sl_h2_0 h1_40) syn_p0_n1
XS_h2_0_41 (vp vn sl_h2_0 h1_41) syn_p1_n0
XS_h2_0_42 (vp vn sl_h2_0 h1_42) syn_p0_n1
XS_h2_0_43 (vp vn sl_h2_0 h1_43) syn_p3_n3
XS_h2_0_44 (vp vn sl_h2_0 h1_44) syn_p3_n3
XS_h2_0_45 (vp vn sl_h2_0 h1_45) syn_p2_n0
XS_h2_0_46 (vp vn sl_h2_0 h1_46) syn_p2_n0
XS_h2_0_47 (vp vn sl_h2_0 h1_47) syn_p3_n3
XS_h2_0_48 (vp vn sl_h2_0 h1_48) syn_p1_n3
XS_h2_0_49 (vp vn sl_h2_0 h1_49) syn_p1_n0
XS_h2_0_50 (vp vn sl_h2_0 h1_50) syn_p0_n1
XS_h2_0_51 (vp vn sl_h2_0 h1_51) syn_p3_n3
XS_h2_0_52 (vp vn sl_h2_0 h1_52) syn_p0_n1
XS_h2_0_53 (vp vn sl_h2_0 h1_53) syn_p0_n1
XS_h2_0_54 (vp vn sl_h2_0 h1_54) syn_p0_n1
XS_h2_0_55 (vp vn sl_h2_0 h1_55) syn_p3_n3
XS_h2_0_56 (vp vn sl_h2_0 h1_56) syn_p0_n2
XS_h2_0_57 (vp vn sl_h2_0 h1_57) syn_p2_n0
XS_h2_0_58 (vp vn sl_h2_0 h1_58) syn_p1_n0
XS_h2_0_59 (vp vn sl_h2_0 h1_59) syn_p1_n0
XS_h2_0_60 (vp vn sl_h2_0 h1_60) syn_p0_n1
XS_h2_0_61 (vp vn sl_h2_0 h1_61) syn_p1_n0
XS_h2_0_62 (vp vn sl_h2_0 h1_62) syn_p1_n3
XS_h2_0_63 (vp vn sl_h2_0 h1_63) syn_p1_n3
XS_h2_1_0 (vp vn sl_h2_1 h1_0) syn_p1_n3
XS_h2_1_1 (vp vn sl_h2_1 h1_1) syn_p3_n3
XS_h2_1_2 (vp vn sl_h2_1 h1_2) syn_p0_n3
XS_h2_1_3 (vp vn sl_h2_1 h1_3) syn_p3_n3
XS_h2_1_4 (vp vn sl_h2_1 h1_4) syn_p0_n1
XS_h2_1_5 (vp vn sl_h2_1 h1_5) syn_p3_n3
XS_h2_1_6 (vp vn sl_h2_1 h1_6) syn_p1_n0
XS_h2_1_7 (vp vn sl_h2_1 h1_7) syn_p0_n2
XS_h2_1_8 (vp vn sl_h2_1 h1_8) syn_p1_n0
XS_h2_1_9 (vp vn sl_h2_1 h1_9) syn_p3_n0
XS_h2_1_10 (vp vn sl_h2_1 h1_10) syn_p0_n1
XS_h2_1_11 (vp vn sl_h2_1 h1_11) syn_p0_n3
XS_h2_1_12 (vp vn sl_h2_1 h1_12) syn_p3_n3
XS_h2_1_13 (vp vn sl_h2_1 h1_13) syn_p2_n0
XS_h2_1_14 (vp vn sl_h2_1 h1_14) syn_p3_n3
XS_h2_1_15 (vp vn sl_h2_1 h1_15) syn_p0_n2
XS_h2_1_16 (vp vn sl_h2_1 h1_16) syn_p2_n0
XS_h2_1_17 (vp vn sl_h2_1 h1_17) syn_p0_n2
XS_h2_1_18 (vp vn sl_h2_1 h1_18) syn_p3_n3
XS_h2_1_19 (vp vn sl_h2_1 h1_19) syn_p0_n1
XS_h2_1_20 (vp vn sl_h2_1 h1_20) syn_p0_n2
XS_h2_1_21 (vp vn sl_h2_1 h1_21) syn_p0_n2
XS_h2_1_22 (vp vn sl_h2_1 h1_22) syn_p3_n3
XS_h2_1_23 (vp vn sl_h2_1 h1_23) syn_p2_n0
XS_h2_1_24 (vp vn sl_h2_1 h1_24) syn_p0_n1
XS_h2_1_25 (vp vn sl_h2_1 h1_25) syn_p2_n0
XS_h2_1_26 (vp vn sl_h2_1 h1_26) syn_p1_n0
XS_h2_1_27 (vp vn sl_h2_1 h1_27) syn_p0_n3
XS_h2_1_28 (vp vn sl_h2_1 h1_28) syn_p0_n1
XS_h2_1_29 (vp vn sl_h2_1 h1_29) syn_p0_n1
XS_h2_1_30 (vp vn sl_h2_1 h1_30) syn_p1_n3
XS_h2_1_31 (vp vn sl_h2_1 h1_31) syn_p3_n3
XS_h2_1_32 (vp vn sl_h2_1 h1_32) syn_p1_n0
XS_h2_1_33 (vp vn sl_h2_1 h1_33) syn_p1_n0
XS_h2_1_34 (vp vn sl_h2_1 h1_34) syn_p1_n3
XS_h2_1_35 (vp vn sl_h2_1 h1_35) syn_p3_n1
XS_h2_1_36 (vp vn sl_h2_1 h1_36) syn_p3_n3
XS_h2_1_37 (vp vn sl_h2_1 h1_37) syn_p1_n0
XS_h2_1_38 (vp vn sl_h2_1 h1_38) syn_p1_n0
XS_h2_1_39 (vp vn sl_h2_1 h1_39) syn_p1_n0
XS_h2_1_40 (vp vn sl_h2_1 h1_40) syn_p0_n3
XS_h2_1_41 (vp vn sl_h2_1 h1_41) syn_p3_n3
XS_h2_1_42 (vp vn sl_h2_1 h1_42) syn_p3_n3
XS_h2_1_43 (vp vn sl_h2_1 h1_43) syn_p3_n3
XS_h2_1_44 (vp vn sl_h2_1 h1_44) syn_p1_n0
XS_h2_1_45 (vp vn sl_h2_1 h1_45) syn_p3_n3
XS_h2_1_46 (vp vn sl_h2_1 h1_46) syn_p0_n1
XS_h2_1_47 (vp vn sl_h2_1 h1_47) syn_p2_n0
XS_h2_1_48 (vp vn sl_h2_1 h1_48) syn_p0_n2
XS_h2_1_49 (vp vn sl_h2_1 h1_49) syn_p2_n0
XS_h2_1_50 (vp vn sl_h2_1 h1_50) syn_p3_n3
XS_h2_1_51 (vp vn sl_h2_1 h1_51) syn_p1_n0
XS_h2_1_52 (vp vn sl_h2_1 h1_52) syn_p3_n3
XS_h2_1_53 (vp vn sl_h2_1 h1_53) syn_p3_n3
XS_h2_1_54 (vp vn sl_h2_1 h1_54) syn_p0_n1
XS_h2_1_55 (vp vn sl_h2_1 h1_55) syn_p2_n0
XS_h2_1_56 (vp vn sl_h2_1 h1_56) syn_p0_n1
XS_h2_1_57 (vp vn sl_h2_1 h1_57) syn_p2_n0
XS_h2_1_58 (vp vn sl_h2_1 h1_58) syn_p0_n1
XS_h2_1_59 (vp vn sl_h2_1 h1_59) syn_p3_n3
XS_h2_1_60 (vp vn sl_h2_1 h1_60) syn_p1_n0
XS_h2_1_61 (vp vn sl_h2_1 h1_61) syn_p0_n1
XS_h2_1_62 (vp vn sl_h2_1 h1_62) syn_p3_n0
XS_h2_1_63 (vp vn sl_h2_1 h1_63) syn_p3_n3
XS_h2_2_0 (vp vn sl_h2_2 h1_0) syn_p0_n2
XS_h2_2_1 (vp vn sl_h2_2 h1_1) syn_p3_n3
XS_h2_2_2 (vp vn sl_h2_2 h1_2) syn_p1_n0
XS_h2_2_3 (vp vn sl_h2_2 h1_3) syn_p1_n0
XS_h2_2_4 (vp vn sl_h2_2 h1_4) syn_p3_n3
XS_h2_2_5 (vp vn sl_h2_2 h1_5) syn_p0_n2
XS_h2_2_6 (vp vn sl_h2_2 h1_6) syn_p2_n0
XS_h2_2_7 (vp vn sl_h2_2 h1_7) syn_p1_n0
XS_h2_2_8 (vp vn sl_h2_2 h1_8) syn_p3_n3
XS_h2_2_9 (vp vn sl_h2_2 h1_9) syn_p2_n0
XS_h2_2_10 (vp vn sl_h2_2 h1_10) syn_p3_n1
XS_h2_2_11 (vp vn sl_h2_2 h1_11) syn_p0_n1
XS_h2_2_12 (vp vn sl_h2_2 h1_12) syn_p2_n0
XS_h2_2_13 (vp vn sl_h2_2 h1_13) syn_p0_n1
XS_h2_2_14 (vp vn sl_h2_2 h1_14) syn_p0_n2
XS_h2_2_15 (vp vn sl_h2_2 h1_15) syn_p0_n1
XS_h2_2_16 (vp vn sl_h2_2 h1_16) syn_p1_n3
XS_h2_2_17 (vp vn sl_h2_2 h1_17) syn_p2_n0
XS_h2_2_18 (vp vn sl_h2_2 h1_18) syn_p3_n3
XS_h2_2_19 (vp vn sl_h2_2 h1_19) syn_p3_n3
XS_h2_2_20 (vp vn sl_h2_2 h1_20) syn_p3_n1
XS_h2_2_21 (vp vn sl_h2_2 h1_21) syn_p3_n3
XS_h2_2_22 (vp vn sl_h2_2 h1_22) syn_p0_n2
XS_h2_2_23 (vp vn sl_h2_2 h1_23) syn_p1_n3
XS_h2_2_24 (vp vn sl_h2_2 h1_24) syn_p0_n2
XS_h2_2_25 (vp vn sl_h2_2 h1_25) syn_p0_n1
XS_h2_2_26 (vp vn sl_h2_2 h1_26) syn_p3_n3
XS_h2_2_27 (vp vn sl_h2_2 h1_27) syn_p2_n0
XS_h2_2_28 (vp vn sl_h2_2 h1_28) syn_p3_n3
XS_h2_2_29 (vp vn sl_h2_2 h1_29) syn_p3_n3
XS_h2_2_30 (vp vn sl_h2_2 h1_30) syn_p0_n2
XS_h2_2_31 (vp vn sl_h2_2 h1_31) syn_p1_n0
XS_h2_2_32 (vp vn sl_h2_2 h1_32) syn_p2_n0
XS_h2_2_33 (vp vn sl_h2_2 h1_33) syn_p0_n2
XS_h2_2_34 (vp vn sl_h2_2 h1_34) syn_p0_n1
XS_h2_2_35 (vp vn sl_h2_2 h1_35) syn_p0_n1
XS_h2_2_36 (vp vn sl_h2_2 h1_36) syn_p0_n2
XS_h2_2_37 (vp vn sl_h2_2 h1_37) syn_p3_n0
XS_h2_2_38 (vp vn sl_h2_2 h1_38) syn_p0_n3
XS_h2_2_39 (vp vn sl_h2_2 h1_39) syn_p3_n3
XS_h2_2_40 (vp vn sl_h2_2 h1_40) syn_p3_n3
XS_h2_2_41 (vp vn sl_h2_2 h1_41) syn_p0_n2
XS_h2_2_42 (vp vn sl_h2_2 h1_42) syn_p3_n1
XS_h2_2_43 (vp vn sl_h2_2 h1_43) syn_p2_n0
XS_h2_2_44 (vp vn sl_h2_2 h1_44) syn_p0_n2
XS_h2_2_45 (vp vn sl_h2_2 h1_45) syn_p0_n1
XS_h2_2_46 (vp vn sl_h2_2 h1_46) syn_p3_n0
XS_h2_2_47 (vp vn sl_h2_2 h1_47) syn_p1_n0
XS_h2_2_48 (vp vn sl_h2_2 h1_48) syn_p0_n1
XS_h2_2_49 (vp vn sl_h2_2 h1_49) syn_p0_n2
XS_h2_2_50 (vp vn sl_h2_2 h1_50) syn_p3_n3
XS_h2_2_51 (vp vn sl_h2_2 h1_51) syn_p0_n1
XS_h2_2_52 (vp vn sl_h2_2 h1_52) syn_p2_n0
XS_h2_2_53 (vp vn sl_h2_2 h1_53) syn_p2_n0
XS_h2_2_54 (vp vn sl_h2_2 h1_54) syn_p1_n0
XS_h2_2_55 (vp vn sl_h2_2 h1_55) syn_p1_n0
XS_h2_2_56 (vp vn sl_h2_2 h1_56) syn_p3_n3
XS_h2_2_57 (vp vn sl_h2_2 h1_57) syn_p0_n2
XS_h2_2_58 (vp vn sl_h2_2 h1_58) syn_p2_n0
XS_h2_2_59 (vp vn sl_h2_2 h1_59) syn_p0_n1
XS_h2_2_60 (vp vn sl_h2_2 h1_60) syn_p3_n3
XS_h2_2_61 (vp vn sl_h2_2 h1_61) syn_p0_n2
XS_h2_2_62 (vp vn sl_h2_2 h1_62) syn_p3_n1
XS_h2_2_63 (vp vn sl_h2_2 h1_63) syn_p3_n3
XS_h2_3_0 (vp vn sl_h2_3 h1_0) syn_p2_n0
XS_h2_3_1 (vp vn sl_h2_3 h1_1) syn_p0_n1
XS_h2_3_2 (vp vn sl_h2_3 h1_2) syn_p0_n3
XS_h2_3_3 (vp vn sl_h2_3 h1_3) syn_p2_n0
XS_h2_3_4 (vp vn sl_h2_3 h1_4) syn_p0_n1
XS_h2_3_5 (vp vn sl_h2_3 h1_5) syn_p1_n0
XS_h2_3_6 (vp vn sl_h2_3 h1_6) syn_p3_n3
XS_h2_3_7 (vp vn sl_h2_3 h1_7) syn_p1_n0
XS_h2_3_8 (vp vn sl_h2_3 h1_8) syn_p3_n3
XS_h2_3_9 (vp vn sl_h2_3 h1_9) syn_p1_n3
XS_h2_3_10 (vp vn sl_h2_3 h1_10) syn_p2_n0
XS_h2_3_11 (vp vn sl_h2_3 h1_11) syn_p3_n3
XS_h2_3_12 (vp vn sl_h2_3 h1_12) syn_p1_n0
XS_h2_3_13 (vp vn sl_h2_3 h1_13) syn_p1_n3
XS_h2_3_14 (vp vn sl_h2_3 h1_14) syn_p3_n3
XS_h2_3_15 (vp vn sl_h2_3 h1_15) syn_p1_n0
XS_h2_3_16 (vp vn sl_h2_3 h1_16) syn_p1_n0
XS_h2_3_17 (vp vn sl_h2_3 h1_17) syn_p0_n1
XS_h2_3_18 (vp vn sl_h2_3 h1_18) syn_p3_n3
XS_h2_3_19 (vp vn sl_h2_3 h1_19) syn_p3_n1
XS_h2_3_20 (vp vn sl_h2_3 h1_20) syn_p1_n0
XS_h2_3_21 (vp vn sl_h2_3 h1_21) syn_p3_n3
XS_h2_3_22 (vp vn sl_h2_3 h1_22) syn_p3_n3
XS_h2_3_23 (vp vn sl_h2_3 h1_23) syn_p3_n3
XS_h2_3_24 (vp vn sl_h2_3 h1_24) syn_p0_n2
XS_h2_3_25 (vp vn sl_h2_3 h1_25) syn_p2_n0
XS_h2_3_26 (vp vn sl_h2_3 h1_26) syn_p0_n1
XS_h2_3_27 (vp vn sl_h2_3 h1_27) syn_p3_n3
XS_h2_3_28 (vp vn sl_h2_3 h1_28) syn_p3_n0
XS_h2_3_29 (vp vn sl_h2_3 h1_29) syn_p1_n0
XS_h2_3_30 (vp vn sl_h2_3 h1_30) syn_p2_n0
XS_h2_3_31 (vp vn sl_h2_3 h1_31) syn_p0_n1
XS_h2_3_32 (vp vn sl_h2_3 h1_32) syn_p3_n3
XS_h2_3_33 (vp vn sl_h2_3 h1_33) syn_p3_n3
XS_h2_3_34 (vp vn sl_h2_3 h1_34) syn_p0_n1
XS_h2_3_35 (vp vn sl_h2_3 h1_35) syn_p1_n0
XS_h2_3_36 (vp vn sl_h2_3 h1_36) syn_p1_n0
XS_h2_3_37 (vp vn sl_h2_3 h1_37) syn_p3_n3
XS_h2_3_38 (vp vn sl_h2_3 h1_38) syn_p0_n1
XS_h2_3_39 (vp vn sl_h2_3 h1_39) syn_p0_n1
XS_h2_3_40 (vp vn sl_h2_3 h1_40) syn_p0_n2
XS_h2_3_41 (vp vn sl_h2_3 h1_41) syn_p3_n3
XS_h2_3_42 (vp vn sl_h2_3 h1_42) syn_p1_n0
XS_h2_3_43 (vp vn sl_h2_3 h1_43) syn_p0_n1
XS_h2_3_44 (vp vn sl_h2_3 h1_44) syn_p0_n2
XS_h2_3_45 (vp vn sl_h2_3 h1_45) syn_p0_n1
XS_h2_3_46 (vp vn sl_h2_3 h1_46) syn_p0_n2
XS_h2_3_47 (vp vn sl_h2_3 h1_47) syn_p0_n2
XS_h2_3_48 (vp vn sl_h2_3 h1_48) syn_p2_n0
XS_h2_3_49 (vp vn sl_h2_3 h1_49) syn_p0_n1
XS_h2_3_50 (vp vn sl_h2_3 h1_50) syn_p3_n3
XS_h2_3_51 (vp vn sl_h2_3 h1_51) syn_p1_n0
XS_h2_3_52 (vp vn sl_h2_3 h1_52) syn_p0_n3
XS_h2_3_53 (vp vn sl_h2_3 h1_53) syn_p0_n3
XS_h2_3_54 (vp vn sl_h2_3 h1_54) syn_p0_n1
XS_h2_3_55 (vp vn sl_h2_3 h1_55) syn_p2_n0
XS_h2_3_56 (vp vn sl_h2_3 h1_56) syn_p1_n0
XS_h2_3_57 (vp vn sl_h2_3 h1_57) syn_p1_n3
XS_h2_3_58 (vp vn sl_h2_3 h1_58) syn_p2_n0
XS_h2_3_59 (vp vn sl_h2_3 h1_59) syn_p0_n1
XS_h2_3_60 (vp vn sl_h2_3 h1_60) syn_p1_n3
XS_h2_3_61 (vp vn sl_h2_3 h1_61) syn_p0_n3
XS_h2_3_62 (vp vn sl_h2_3 h1_62) syn_p0_n1
XS_h2_3_63 (vp vn sl_h2_3 h1_63) syn_p2_n0
XS_h2_4_0 (vp vn sl_h2_4 h1_0) syn_p3_n3
XS_h2_4_1 (vp vn sl_h2_4 h1_1) syn_p1_n3
XS_h2_4_2 (vp vn sl_h2_4 h1_2) syn_p3_n3
XS_h2_4_3 (vp vn sl_h2_4 h1_3) syn_p3_n3
XS_h2_4_4 (vp vn sl_h2_4 h1_4) syn_p0_n1
XS_h2_4_5 (vp vn sl_h2_4 h1_5) syn_p3_n3
XS_h2_4_6 (vp vn sl_h2_4 h1_6) syn_p0_n1
XS_h2_4_7 (vp vn sl_h2_4 h1_7) syn_p3_n3
XS_h2_4_8 (vp vn sl_h2_4 h1_8) syn_p3_n0
XS_h2_4_9 (vp vn sl_h2_4 h1_9) syn_p3_n3
XS_h2_4_10 (vp vn sl_h2_4 h1_10) syn_p0_n2
XS_h2_4_11 (vp vn sl_h2_4 h1_11) syn_p1_n0
XS_h2_4_12 (vp vn sl_h2_4 h1_12) syn_p0_n1
XS_h2_4_13 (vp vn sl_h2_4 h1_13) syn_p3_n3
XS_h2_4_14 (vp vn sl_h2_4 h1_14) syn_p1_n0
XS_h2_4_15 (vp vn sl_h2_4 h1_15) syn_p3_n3
XS_h2_4_16 (vp vn sl_h2_4 h1_16) syn_p1_n0
XS_h2_4_17 (vp vn sl_h2_4 h1_17) syn_p3_n3
XS_h2_4_18 (vp vn sl_h2_4 h1_18) syn_p3_n1
XS_h2_4_19 (vp vn sl_h2_4 h1_19) syn_p2_n0
XS_h2_4_20 (vp vn sl_h2_4 h1_20) syn_p1_n0
XS_h2_4_21 (vp vn sl_h2_4 h1_21) syn_p2_n0
XS_h2_4_22 (vp vn sl_h2_4 h1_22) syn_p0_n2
XS_h2_4_23 (vp vn sl_h2_4 h1_23) syn_p3_n1
XS_h2_4_24 (vp vn sl_h2_4 h1_24) syn_p3_n1
XS_h2_4_25 (vp vn sl_h2_4 h1_25) syn_p1_n0
XS_h2_4_26 (vp vn sl_h2_4 h1_26) syn_p1_n0
XS_h2_4_27 (vp vn sl_h2_4 h1_27) syn_p3_n3
XS_h2_4_28 (vp vn sl_h2_4 h1_28) syn_p2_n0
XS_h2_4_29 (vp vn sl_h2_4 h1_29) syn_p1_n0
XS_h2_4_30 (vp vn sl_h2_4 h1_30) syn_p0_n1
XS_h2_4_31 (vp vn sl_h2_4 h1_31) syn_p2_n0
XS_h2_4_32 (vp vn sl_h2_4 h1_32) syn_p2_n0
XS_h2_4_33 (vp vn sl_h2_4 h1_33) syn_p3_n3
XS_h2_4_34 (vp vn sl_h2_4 h1_34) syn_p0_n2
XS_h2_4_35 (vp vn sl_h2_4 h1_35) syn_p0_n1
XS_h2_4_36 (vp vn sl_h2_4 h1_36) syn_p2_n0
XS_h2_4_37 (vp vn sl_h2_4 h1_37) syn_p3_n3
XS_h2_4_38 (vp vn sl_h2_4 h1_38) syn_p1_n0
XS_h2_4_39 (vp vn sl_h2_4 h1_39) syn_p3_n1
XS_h2_4_40 (vp vn sl_h2_4 h1_40) syn_p3_n3
XS_h2_4_41 (vp vn sl_h2_4 h1_41) syn_p1_n0
XS_h2_4_42 (vp vn sl_h2_4 h1_42) syn_p0_n1
XS_h2_4_43 (vp vn sl_h2_4 h1_43) syn_p2_n0
XS_h2_4_44 (vp vn sl_h2_4 h1_44) syn_p3_n1
XS_h2_4_45 (vp vn sl_h2_4 h1_45) syn_p1_n0
XS_h2_4_46 (vp vn sl_h2_4 h1_46) syn_p3_n1
XS_h2_4_47 (vp vn sl_h2_4 h1_47) syn_p1_n3
XS_h2_4_48 (vp vn sl_h2_4 h1_48) syn_p2_n0
XS_h2_4_49 (vp vn sl_h2_4 h1_49) syn_p3_n0
XS_h2_4_50 (vp vn sl_h2_4 h1_50) syn_p0_n2
XS_h2_4_51 (vp vn sl_h2_4 h1_51) syn_p0_n1
XS_h2_4_52 (vp vn sl_h2_4 h1_52) syn_p3_n1
XS_h2_4_53 (vp vn sl_h2_4 h1_53) syn_p3_n0
XS_h2_4_54 (vp vn sl_h2_4 h1_54) syn_p2_n0
XS_h2_4_55 (vp vn sl_h2_4 h1_55) syn_p0_n1
XS_h2_4_56 (vp vn sl_h2_4 h1_56) syn_p2_n0
XS_h2_4_57 (vp vn sl_h2_4 h1_57) syn_p1_n3
XS_h2_4_58 (vp vn sl_h2_4 h1_58) syn_p2_n0
XS_h2_4_59 (vp vn sl_h2_4 h1_59) syn_p0_n1
XS_h2_4_60 (vp vn sl_h2_4 h1_60) syn_p3_n1
XS_h2_4_61 (vp vn sl_h2_4 h1_61) syn_p3_n3
XS_h2_4_62 (vp vn sl_h2_4 h1_62) syn_p1_n0
XS_h2_4_63 (vp vn sl_h2_4 h1_63) syn_p1_n0
XS_h2_5_0 (vp vn sl_h2_5 h1_0) syn_p3_n3
XS_h2_5_1 (vp vn sl_h2_5 h1_1) syn_p3_n3
XS_h2_5_2 (vp vn sl_h2_5 h1_2) syn_p0_n2
XS_h2_5_3 (vp vn sl_h2_5 h1_3) syn_p2_n0
XS_h2_5_4 (vp vn sl_h2_5 h1_4) syn_p1_n3
XS_h2_5_5 (vp vn sl_h2_5 h1_5) syn_p0_n2
XS_h2_5_6 (vp vn sl_h2_5 h1_6) syn_p1_n0
XS_h2_5_7 (vp vn sl_h2_5 h1_7) syn_p1_n0
XS_h2_5_8 (vp vn sl_h2_5 h1_8) syn_p3_n1
XS_h2_5_9 (vp vn sl_h2_5 h1_9) syn_p1_n0
XS_h2_5_10 (vp vn sl_h2_5 h1_10) syn_p3_n3
XS_h2_5_11 (vp vn sl_h2_5 h1_11) syn_p0_n2
XS_h2_5_12 (vp vn sl_h2_5 h1_12) syn_p2_n0
XS_h2_5_13 (vp vn sl_h2_5 h1_13) syn_p3_n3
XS_h2_5_14 (vp vn sl_h2_5 h1_14) syn_p3_n3
XS_h2_5_15 (vp vn sl_h2_5 h1_15) syn_p1_n0
XS_h2_5_16 (vp vn sl_h2_5 h1_16) syn_p0_n1
XS_h2_5_17 (vp vn sl_h2_5 h1_17) syn_p1_n3
XS_h2_5_18 (vp vn sl_h2_5 h1_18) syn_p1_n3
XS_h2_5_19 (vp vn sl_h2_5 h1_19) syn_p3_n3
XS_h2_5_20 (vp vn sl_h2_5 h1_20) syn_p3_n3
XS_h2_5_21 (vp vn sl_h2_5 h1_21) syn_p3_n3
XS_h2_5_22 (vp vn sl_h2_5 h1_22) syn_p0_n2
XS_h2_5_23 (vp vn sl_h2_5 h1_23) syn_p0_n2
XS_h2_5_24 (vp vn sl_h2_5 h1_24) syn_p3_n3
XS_h2_5_25 (vp vn sl_h2_5 h1_25) syn_p0_n1
XS_h2_5_26 (vp vn sl_h2_5 h1_26) syn_p0_n1
XS_h2_5_27 (vp vn sl_h2_5 h1_27) syn_p2_n0
XS_h2_5_28 (vp vn sl_h2_5 h1_28) syn_p2_n0
XS_h2_5_29 (vp vn sl_h2_5 h1_29) syn_p2_n0
XS_h2_5_30 (vp vn sl_h2_5 h1_30) syn_p3_n0
XS_h2_5_31 (vp vn sl_h2_5 h1_31) syn_p3_n3
XS_h2_5_32 (vp vn sl_h2_5 h1_32) syn_p2_n0
XS_h2_5_33 (vp vn sl_h2_5 h1_33) syn_p0_n1
XS_h2_5_34 (vp vn sl_h2_5 h1_34) syn_p0_n3
XS_h2_5_35 (vp vn sl_h2_5 h1_35) syn_p3_n3
XS_h2_5_36 (vp vn sl_h2_5 h1_36) syn_p3_n3
XS_h2_5_37 (vp vn sl_h2_5 h1_37) syn_p0_n2
XS_h2_5_38 (vp vn sl_h2_5 h1_38) syn_p0_n1
XS_h2_5_39 (vp vn sl_h2_5 h1_39) syn_p2_n0
XS_h2_5_40 (vp vn sl_h2_5 h1_40) syn_p0_n1
XS_h2_5_41 (vp vn sl_h2_5 h1_41) syn_p3_n3
XS_h2_5_42 (vp vn sl_h2_5 h1_42) syn_p1_n0
XS_h2_5_43 (vp vn sl_h2_5 h1_43) syn_p2_n0
XS_h2_5_44 (vp vn sl_h2_5 h1_44) syn_p2_n0
XS_h2_5_45 (vp vn sl_h2_5 h1_45) syn_p3_n1
XS_h2_5_46 (vp vn sl_h2_5 h1_46) syn_p0_n2
XS_h2_5_47 (vp vn sl_h2_5 h1_47) syn_p2_n0
XS_h2_5_48 (vp vn sl_h2_5 h1_48) syn_p0_n1
XS_h2_5_49 (vp vn sl_h2_5 h1_49) syn_p1_n0
XS_h2_5_50 (vp vn sl_h2_5 h1_50) syn_p1_n0
XS_h2_5_51 (vp vn sl_h2_5 h1_51) syn_p1_n0
XS_h2_5_52 (vp vn sl_h2_5 h1_52) syn_p0_n1
XS_h2_5_53 (vp vn sl_h2_5 h1_53) syn_p0_n2
XS_h2_5_54 (vp vn sl_h2_5 h1_54) syn_p1_n0
XS_h2_5_55 (vp vn sl_h2_5 h1_55) syn_p0_n2
XS_h2_5_56 (vp vn sl_h2_5 h1_56) syn_p0_n1
XS_h2_5_57 (vp vn sl_h2_5 h1_57) syn_p0_n3
XS_h2_5_58 (vp vn sl_h2_5 h1_58) syn_p0_n1
XS_h2_5_59 (vp vn sl_h2_5 h1_59) syn_p0_n1
XS_h2_5_60 (vp vn sl_h2_5 h1_60) syn_p0_n1
XS_h2_5_61 (vp vn sl_h2_5 h1_61) syn_p0_n2
XS_h2_5_62 (vp vn sl_h2_5 h1_62) syn_p3_n3
XS_h2_5_63 (vp vn sl_h2_5 h1_63) syn_p3_n1
XS_h2_6_0 (vp vn sl_h2_6 h1_0) syn_p0_n1
XS_h2_6_1 (vp vn sl_h2_6 h1_1) syn_p2_n0
XS_h2_6_2 (vp vn sl_h2_6 h1_2) syn_p1_n0
XS_h2_6_3 (vp vn sl_h2_6 h1_3) syn_p0_n2
XS_h2_6_4 (vp vn sl_h2_6 h1_4) syn_p1_n3
XS_h2_6_5 (vp vn sl_h2_6 h1_5) syn_p3_n3
XS_h2_6_6 (vp vn sl_h2_6 h1_6) syn_p3_n0
XS_h2_6_7 (vp vn sl_h2_6 h1_7) syn_p0_n1
XS_h2_6_8 (vp vn sl_h2_6 h1_8) syn_p3_n3
XS_h2_6_9 (vp vn sl_h2_6 h1_9) syn_p0_n2
XS_h2_6_10 (vp vn sl_h2_6 h1_10) syn_p3_n3
XS_h2_6_11 (vp vn sl_h2_6 h1_11) syn_p0_n2
XS_h2_6_12 (vp vn sl_h2_6 h1_12) syn_p0_n1
XS_h2_6_13 (vp vn sl_h2_6 h1_13) syn_p1_n3
XS_h2_6_14 (vp vn sl_h2_6 h1_14) syn_p3_n3
XS_h2_6_15 (vp vn sl_h2_6 h1_15) syn_p0_n2
XS_h2_6_16 (vp vn sl_h2_6 h1_16) syn_p3_n3
XS_h2_6_17 (vp vn sl_h2_6 h1_17) syn_p0_n3
XS_h2_6_18 (vp vn sl_h2_6 h1_18) syn_p3_n1
XS_h2_6_19 (vp vn sl_h2_6 h1_19) syn_p1_n0
XS_h2_6_20 (vp vn sl_h2_6 h1_20) syn_p3_n3
XS_h2_6_21 (vp vn sl_h2_6 h1_21) syn_p0_n1
XS_h2_6_22 (vp vn sl_h2_6 h1_22) syn_p0_n2
XS_h2_6_23 (vp vn sl_h2_6 h1_23) syn_p2_n0
XS_h2_6_24 (vp vn sl_h2_6 h1_24) syn_p0_n2
XS_h2_6_25 (vp vn sl_h2_6 h1_25) syn_p0_n2
XS_h2_6_26 (vp vn sl_h2_6 h1_26) syn_p0_n3
XS_h2_6_27 (vp vn sl_h2_6 h1_27) syn_p0_n1
XS_h2_6_28 (vp vn sl_h2_6 h1_28) syn_p3_n3
XS_h2_6_29 (vp vn sl_h2_6 h1_29) syn_p1_n3
XS_h2_6_30 (vp vn sl_h2_6 h1_30) syn_p2_n0
XS_h2_6_31 (vp vn sl_h2_6 h1_31) syn_p3_n3
XS_h2_6_32 (vp vn sl_h2_6 h1_32) syn_p3_n3
XS_h2_6_33 (vp vn sl_h2_6 h1_33) syn_p3_n3
XS_h2_6_34 (vp vn sl_h2_6 h1_34) syn_p3_n0
XS_h2_6_35 (vp vn sl_h2_6 h1_35) syn_p0_n1
XS_h2_6_36 (vp vn sl_h2_6 h1_36) syn_p0_n2
XS_h2_6_37 (vp vn sl_h2_6 h1_37) syn_p3_n3
XS_h2_6_38 (vp vn sl_h2_6 h1_38) syn_p0_n1
XS_h2_6_39 (vp vn sl_h2_6 h1_39) syn_p1_n0
XS_h2_6_40 (vp vn sl_h2_6 h1_40) syn_p0_n2
XS_h2_6_41 (vp vn sl_h2_6 h1_41) syn_p3_n3
XS_h2_6_42 (vp vn sl_h2_6 h1_42) syn_p0_n2
XS_h2_6_43 (vp vn sl_h2_6 h1_43) syn_p1_n0
XS_h2_6_44 (vp vn sl_h2_6 h1_44) syn_p0_n1
XS_h2_6_45 (vp vn sl_h2_6 h1_45) syn_p2_n0
XS_h2_6_46 (vp vn sl_h2_6 h1_46) syn_p3_n3
XS_h2_6_47 (vp vn sl_h2_6 h1_47) syn_p1_n0
XS_h2_6_48 (vp vn sl_h2_6 h1_48) syn_p3_n3
XS_h2_6_49 (vp vn sl_h2_6 h1_49) syn_p0_n2
XS_h2_6_50 (vp vn sl_h2_6 h1_50) syn_p3_n3
XS_h2_6_51 (vp vn sl_h2_6 h1_51) syn_p3_n1
XS_h2_6_52 (vp vn sl_h2_6 h1_52) syn_p0_n1
XS_h2_6_53 (vp vn sl_h2_6 h1_53) syn_p0_n1
XS_h2_6_54 (vp vn sl_h2_6 h1_54) syn_p3_n3
XS_h2_6_55 (vp vn sl_h2_6 h1_55) syn_p0_n1
XS_h2_6_56 (vp vn sl_h2_6 h1_56) syn_p2_n0
XS_h2_6_57 (vp vn sl_h2_6 h1_57) syn_p0_n1
XS_h2_6_58 (vp vn sl_h2_6 h1_58) syn_p0_n2
XS_h2_6_59 (vp vn sl_h2_6 h1_59) syn_p3_n3
XS_h2_6_60 (vp vn sl_h2_6 h1_60) syn_p2_n0
XS_h2_6_61 (vp vn sl_h2_6 h1_61) syn_p2_n0
XS_h2_6_62 (vp vn sl_h2_6 h1_62) syn_p0_n1
XS_h2_6_63 (vp vn sl_h2_6 h1_63) syn_p3_n3
XS_h2_7_0 (vp vn sl_h2_7 h1_0) syn_p0_n2
XS_h2_7_1 (vp vn sl_h2_7 h1_1) syn_p1_n0
XS_h2_7_2 (vp vn sl_h2_7 h1_2) syn_p0_n2
XS_h2_7_3 (vp vn sl_h2_7 h1_3) syn_p1_n0
XS_h2_7_4 (vp vn sl_h2_7 h1_4) syn_p1_n3
XS_h2_7_5 (vp vn sl_h2_7 h1_5) syn_p2_n0
XS_h2_7_6 (vp vn sl_h2_7 h1_6) syn_p3_n3
XS_h2_7_7 (vp vn sl_h2_7 h1_7) syn_p3_n3
XS_h2_7_8 (vp vn sl_h2_7 h1_8) syn_p1_n3
XS_h2_7_9 (vp vn sl_h2_7 h1_9) syn_p0_n3
XS_h2_7_10 (vp vn sl_h2_7 h1_10) syn_p0_n1
XS_h2_7_11 (vp vn sl_h2_7 h1_11) syn_p3_n1
XS_h2_7_12 (vp vn sl_h2_7 h1_12) syn_p1_n0
XS_h2_7_13 (vp vn sl_h2_7 h1_13) syn_p3_n3
XS_h2_7_14 (vp vn sl_h2_7 h1_14) syn_p0_n2
XS_h2_7_15 (vp vn sl_h2_7 h1_15) syn_p2_n0
XS_h2_7_16 (vp vn sl_h2_7 h1_16) syn_p0_n2
XS_h2_7_17 (vp vn sl_h2_7 h1_17) syn_p3_n3
XS_h2_7_18 (vp vn sl_h2_7 h1_18) syn_p1_n0
XS_h2_7_19 (vp vn sl_h2_7 h1_19) syn_p0_n2
XS_h2_7_20 (vp vn sl_h2_7 h1_20) syn_p2_n0
XS_h2_7_21 (vp vn sl_h2_7 h1_21) syn_p0_n1
XS_h2_7_22 (vp vn sl_h2_7 h1_22) syn_p3_n1
XS_h2_7_23 (vp vn sl_h2_7 h1_23) syn_p3_n1
XS_h2_7_24 (vp vn sl_h2_7 h1_24) syn_p2_n0
XS_h2_7_25 (vp vn sl_h2_7 h1_25) syn_p1_n0
XS_h2_7_26 (vp vn sl_h2_7 h1_26) syn_p0_n2
XS_h2_7_27 (vp vn sl_h2_7 h1_27) syn_p0_n1
XS_h2_7_28 (vp vn sl_h2_7 h1_28) syn_p3_n3
XS_h2_7_29 (vp vn sl_h2_7 h1_29) syn_p3_n0
XS_h2_7_30 (vp vn sl_h2_7 h1_30) syn_p3_n3
XS_h2_7_31 (vp vn sl_h2_7 h1_31) syn_p3_n3
XS_h2_7_32 (vp vn sl_h2_7 h1_32) syn_p1_n3
XS_h2_7_33 (vp vn sl_h2_7 h1_33) syn_p1_n3
XS_h2_7_34 (vp vn sl_h2_7 h1_34) syn_p2_n0
XS_h2_7_35 (vp vn sl_h2_7 h1_35) syn_p3_n1
XS_h2_7_36 (vp vn sl_h2_7 h1_36) syn_p1_n0
XS_h2_7_37 (vp vn sl_h2_7 h1_37) syn_p0_n2
XS_h2_7_38 (vp vn sl_h2_7 h1_38) syn_p2_n0
XS_h2_7_39 (vp vn sl_h2_7 h1_39) syn_p0_n1
XS_h2_7_40 (vp vn sl_h2_7 h1_40) syn_p2_n0
XS_h2_7_41 (vp vn sl_h2_7 h1_41) syn_p1_n0
XS_h2_7_42 (vp vn sl_h2_7 h1_42) syn_p3_n1
XS_h2_7_43 (vp vn sl_h2_7 h1_43) syn_p3_n3
XS_h2_7_44 (vp vn sl_h2_7 h1_44) syn_p0_n2
XS_h2_7_45 (vp vn sl_h2_7 h1_45) syn_p3_n3
XS_h2_7_46 (vp vn sl_h2_7 h1_46) syn_p0_n1
XS_h2_7_47 (vp vn sl_h2_7 h1_47) syn_p0_n2
XS_h2_7_48 (vp vn sl_h2_7 h1_48) syn_p3_n3
XS_h2_7_49 (vp vn sl_h2_7 h1_49) syn_p1_n0
XS_h2_7_50 (vp vn sl_h2_7 h1_50) syn_p3_n3
XS_h2_7_51 (vp vn sl_h2_7 h1_51) syn_p2_n0
XS_h2_7_52 (vp vn sl_h2_7 h1_52) syn_p1_n0
XS_h2_7_53 (vp vn sl_h2_7 h1_53) syn_p2_n0
XS_h2_7_54 (vp vn sl_h2_7 h1_54) syn_p3_n3
XS_h2_7_55 (vp vn sl_h2_7 h1_55) syn_p1_n0
XS_h2_7_56 (vp vn sl_h2_7 h1_56) syn_p3_n3
XS_h2_7_57 (vp vn sl_h2_7 h1_57) syn_p0_n1
XS_h2_7_58 (vp vn sl_h2_7 h1_58) syn_p2_n0
XS_h2_7_59 (vp vn sl_h2_7 h1_59) syn_p0_n2
XS_h2_7_60 (vp vn sl_h2_7 h1_60) syn_p3_n3
XS_h2_7_61 (vp vn sl_h2_7 h1_61) syn_p0_n2
XS_h2_7_62 (vp vn sl_h2_7 h1_62) syn_p0_n1
XS_h2_7_63 (vp vn sl_h2_7 h1_63) syn_p3_n3
XS_h2_8_0 (vp vn sl_h2_8 h1_0) syn_p3_n1
XS_h2_8_1 (vp vn sl_h2_8 h1_1) syn_p3_n3
XS_h2_8_2 (vp vn sl_h2_8 h1_2) syn_p3_n3
XS_h2_8_3 (vp vn sl_h2_8 h1_3) syn_p0_n3
XS_h2_8_4 (vp vn sl_h2_8 h1_4) syn_p1_n3
XS_h2_8_5 (vp vn sl_h2_8 h1_5) syn_p1_n0
XS_h2_8_6 (vp vn sl_h2_8 h1_6) syn_p1_n0
XS_h2_8_7 (vp vn sl_h2_8 h1_7) syn_p0_n1
XS_h2_8_8 (vp vn sl_h2_8 h1_8) syn_p2_n0
XS_h2_8_9 (vp vn sl_h2_8 h1_9) syn_p3_n3
XS_h2_8_10 (vp vn sl_h2_8 h1_10) syn_p0_n2
XS_h2_8_11 (vp vn sl_h2_8 h1_11) syn_p0_n2
XS_h2_8_12 (vp vn sl_h2_8 h1_12) syn_p0_n2
XS_h2_8_13 (vp vn sl_h2_8 h1_13) syn_p0_n2
XS_h2_8_14 (vp vn sl_h2_8 h1_14) syn_p3_n3
XS_h2_8_15 (vp vn sl_h2_8 h1_15) syn_p1_n0
XS_h2_8_16 (vp vn sl_h2_8 h1_16) syn_p3_n1
XS_h2_8_17 (vp vn sl_h2_8 h1_17) syn_p1_n3
XS_h2_8_18 (vp vn sl_h2_8 h1_18) syn_p3_n3
XS_h2_8_19 (vp vn sl_h2_8 h1_19) syn_p0_n1
XS_h2_8_20 (vp vn sl_h2_8 h1_20) syn_p0_n1
XS_h2_8_21 (vp vn sl_h2_8 h1_21) syn_p0_n2
XS_h2_8_22 (vp vn sl_h2_8 h1_22) syn_p0_n2
XS_h2_8_23 (vp vn sl_h2_8 h1_23) syn_p3_n3
XS_h2_8_24 (vp vn sl_h2_8 h1_24) syn_p3_n3
XS_h2_8_25 (vp vn sl_h2_8 h1_25) syn_p1_n0
XS_h2_8_26 (vp vn sl_h2_8 h1_26) syn_p0_n2
XS_h2_8_27 (vp vn sl_h2_8 h1_27) syn_p0_n2
XS_h2_8_28 (vp vn sl_h2_8 h1_28) syn_p1_n0
XS_h2_8_29 (vp vn sl_h2_8 h1_29) syn_p3_n3
XS_h2_8_30 (vp vn sl_h2_8 h1_30) syn_p1_n0
XS_h2_8_31 (vp vn sl_h2_8 h1_31) syn_p1_n0
XS_h2_8_32 (vp vn sl_h2_8 h1_32) syn_p1_n0
XS_h2_8_33 (vp vn sl_h2_8 h1_33) syn_p1_n0
XS_h2_8_34 (vp vn sl_h2_8 h1_34) syn_p2_n0
XS_h2_8_35 (vp vn sl_h2_8 h1_35) syn_p0_n1
XS_h2_8_36 (vp vn sl_h2_8 h1_36) syn_p0_n1
XS_h2_8_37 (vp vn sl_h2_8 h1_37) syn_p1_n3
XS_h2_8_38 (vp vn sl_h2_8 h1_38) syn_p3_n3
XS_h2_8_39 (vp vn sl_h2_8 h1_39) syn_p2_n0
XS_h2_8_40 (vp vn sl_h2_8 h1_40) syn_p1_n0
XS_h2_8_41 (vp vn sl_h2_8 h1_41) syn_p0_n3
XS_h2_8_42 (vp vn sl_h2_8 h1_42) syn_p3_n3
XS_h2_8_43 (vp vn sl_h2_8 h1_43) syn_p0_n1
XS_h2_8_44 (vp vn sl_h2_8 h1_44) syn_p0_n2
XS_h2_8_45 (vp vn sl_h2_8 h1_45) syn_p2_n0
XS_h2_8_46 (vp vn sl_h2_8 h1_46) syn_p0_n1
XS_h2_8_47 (vp vn sl_h2_8 h1_47) syn_p3_n3
XS_h2_8_48 (vp vn sl_h2_8 h1_48) syn_p3_n0
XS_h2_8_49 (vp vn sl_h2_8 h1_49) syn_p3_n3
XS_h2_8_50 (vp vn sl_h2_8 h1_50) syn_p0_n1
XS_h2_8_51 (vp vn sl_h2_8 h1_51) syn_p3_n3
XS_h2_8_52 (vp vn sl_h2_8 h1_52) syn_p0_n3
XS_h2_8_53 (vp vn sl_h2_8 h1_53) syn_p1_n3
XS_h2_8_54 (vp vn sl_h2_8 h1_54) syn_p1_n0
XS_h2_8_55 (vp vn sl_h2_8 h1_55) syn_p0_n1
XS_h2_8_56 (vp vn sl_h2_8 h1_56) syn_p3_n3
XS_h2_8_57 (vp vn sl_h2_8 h1_57) syn_p1_n0
XS_h2_8_58 (vp vn sl_h2_8 h1_58) syn_p1_n3
XS_h2_8_59 (vp vn sl_h2_8 h1_59) syn_p0_n1
XS_h2_8_60 (vp vn sl_h2_8 h1_60) syn_p3_n3
XS_h2_8_61 (vp vn sl_h2_8 h1_61) syn_p0_n1
XS_h2_8_62 (vp vn sl_h2_8 h1_62) syn_p3_n3
XS_h2_8_63 (vp vn sl_h2_8 h1_63) syn_p1_n0
XS_h2_9_0 (vp vn sl_h2_9 h1_0) syn_p0_n1
XS_h2_9_1 (vp vn sl_h2_9 h1_1) syn_p2_n0
XS_h2_9_2 (vp vn sl_h2_9 h1_2) syn_p1_n0
XS_h2_9_3 (vp vn sl_h2_9 h1_3) syn_p0_n1
XS_h2_9_4 (vp vn sl_h2_9 h1_4) syn_p1_n0
XS_h2_9_5 (vp vn sl_h2_9 h1_5) syn_p2_n0
XS_h2_9_6 (vp vn sl_h2_9 h1_6) syn_p0_n1
XS_h2_9_7 (vp vn sl_h2_9 h1_7) syn_p2_n0
XS_h2_9_8 (vp vn sl_h2_9 h1_8) syn_p0_n2
XS_h2_9_9 (vp vn sl_h2_9 h1_9) syn_p2_n0
XS_h2_9_10 (vp vn sl_h2_9 h1_10) syn_p0_n1
XS_h2_9_11 (vp vn sl_h2_9 h1_11) syn_p0_n1
XS_h2_9_12 (vp vn sl_h2_9 h1_12) syn_p3_n3
XS_h2_9_13 (vp vn sl_h2_9 h1_13) syn_p0_n1
XS_h2_9_14 (vp vn sl_h2_9 h1_14) syn_p1_n3
XS_h2_9_15 (vp vn sl_h2_9 h1_15) syn_p2_n0
XS_h2_9_16 (vp vn sl_h2_9 h1_16) syn_p3_n1
XS_h2_9_17 (vp vn sl_h2_9 h1_17) syn_p0_n1
XS_h2_9_18 (vp vn sl_h2_9 h1_18) syn_p0_n1
XS_h2_9_19 (vp vn sl_h2_9 h1_19) syn_p0_n2
XS_h2_9_20 (vp vn sl_h2_9 h1_20) syn_p1_n0
XS_h2_9_21 (vp vn sl_h2_9 h1_21) syn_p0_n2
XS_h2_9_22 (vp vn sl_h2_9 h1_22) syn_p0_n1
XS_h2_9_23 (vp vn sl_h2_9 h1_23) syn_p0_n1
XS_h2_9_24 (vp vn sl_h2_9 h1_24) syn_p1_n0
XS_h2_9_25 (vp vn sl_h2_9 h1_25) syn_p1_n0
XS_h2_9_26 (vp vn sl_h2_9 h1_26) syn_p3_n3
XS_h2_9_27 (vp vn sl_h2_9 h1_27) syn_p0_n2
XS_h2_9_28 (vp vn sl_h2_9 h1_28) syn_p0_n2
XS_h2_9_29 (vp vn sl_h2_9 h1_29) syn_p3_n3
XS_h2_9_30 (vp vn sl_h2_9 h1_30) syn_p2_n0
XS_h2_9_31 (vp vn sl_h2_9 h1_31) syn_p2_n0
XS_h2_9_32 (vp vn sl_h2_9 h1_32) syn_p2_n0
XS_h2_9_33 (vp vn sl_h2_9 h1_33) syn_p0_n2
XS_h2_9_34 (vp vn sl_h2_9 h1_34) syn_p0_n2
XS_h2_9_35 (vp vn sl_h2_9 h1_35) syn_p2_n0
XS_h2_9_36 (vp vn sl_h2_9 h1_36) syn_p3_n3
XS_h2_9_37 (vp vn sl_h2_9 h1_37) syn_p3_n1
XS_h2_9_38 (vp vn sl_h2_9 h1_38) syn_p0_n2
XS_h2_9_39 (vp vn sl_h2_9 h1_39) syn_p1_n0
XS_h2_9_40 (vp vn sl_h2_9 h1_40) syn_p3_n3
XS_h2_9_41 (vp vn sl_h2_9 h1_41) syn_p2_n0
XS_h2_9_42 (vp vn sl_h2_9 h1_42) syn_p1_n0
XS_h2_9_43 (vp vn sl_h2_9 h1_43) syn_p3_n3
XS_h2_9_44 (vp vn sl_h2_9 h1_44) syn_p3_n1
XS_h2_9_45 (vp vn sl_h2_9 h1_45) syn_p0_n2
XS_h2_9_46 (vp vn sl_h2_9 h1_46) syn_p2_n0
XS_h2_9_47 (vp vn sl_h2_9 h1_47) syn_p1_n3
XS_h2_9_48 (vp vn sl_h2_9 h1_48) syn_p1_n0
XS_h2_9_49 (vp vn sl_h2_9 h1_49) syn_p3_n1
XS_h2_9_50 (vp vn sl_h2_9 h1_50) syn_p3_n0
XS_h2_9_51 (vp vn sl_h2_9 h1_51) syn_p2_n0
XS_h2_9_52 (vp vn sl_h2_9 h1_52) syn_p1_n3
XS_h2_9_53 (vp vn sl_h2_9 h1_53) syn_p2_n0
XS_h2_9_54 (vp vn sl_h2_9 h1_54) syn_p0_n1
XS_h2_9_55 (vp vn sl_h2_9 h1_55) syn_p3_n3
XS_h2_9_56 (vp vn sl_h2_9 h1_56) syn_p3_n3
XS_h2_9_57 (vp vn sl_h2_9 h1_57) syn_p0_n1
XS_h2_9_58 (vp vn sl_h2_9 h1_58) syn_p1_n0
XS_h2_9_59 (vp vn sl_h2_9 h1_59) syn_p0_n1
XS_h2_9_60 (vp vn sl_h2_9 h1_60) syn_p1_n3
XS_h2_9_61 (vp vn sl_h2_9 h1_61) syn_p3_n3
XS_h2_9_62 (vp vn sl_h2_9 h1_62) syn_p3_n0
XS_h2_9_63 (vp vn sl_h2_9 h1_63) syn_p0_n3
XS_h2_10_0 (vp vn sl_h2_10 h1_0) syn_p0_n3
XS_h2_10_1 (vp vn sl_h2_10 h1_1) syn_p0_n2
XS_h2_10_2 (vp vn sl_h2_10 h1_2) syn_p0_n1
XS_h2_10_3 (vp vn sl_h2_10 h1_3) syn_p1_n0
XS_h2_10_4 (vp vn sl_h2_10 h1_4) syn_p3_n3
XS_h2_10_5 (vp vn sl_h2_10 h1_5) syn_p3_n3
XS_h2_10_6 (vp vn sl_h2_10 h1_6) syn_p0_n2
XS_h2_10_7 (vp vn sl_h2_10 h1_7) syn_p3_n3
XS_h2_10_8 (vp vn sl_h2_10 h1_8) syn_p2_n0
XS_h2_10_9 (vp vn sl_h2_10 h1_9) syn_p0_n2
XS_h2_10_10 (vp vn sl_h2_10 h1_10) syn_p0_n2
XS_h2_10_11 (vp vn sl_h2_10 h1_11) syn_p0_n1
XS_h2_10_12 (vp vn sl_h2_10 h1_12) syn_p3_n3
XS_h2_10_13 (vp vn sl_h2_10 h1_13) syn_p0_n2
XS_h2_10_14 (vp vn sl_h2_10 h1_14) syn_p1_n0
XS_h2_10_15 (vp vn sl_h2_10 h1_15) syn_p1_n0
XS_h2_10_16 (vp vn sl_h2_10 h1_16) syn_p2_n0
XS_h2_10_17 (vp vn sl_h2_10 h1_17) syn_p0_n1
XS_h2_10_18 (vp vn sl_h2_10 h1_18) syn_p0_n1
XS_h2_10_19 (vp vn sl_h2_10 h1_19) syn_p3_n3
XS_h2_10_20 (vp vn sl_h2_10 h1_20) syn_p0_n2
XS_h2_10_21 (vp vn sl_h2_10 h1_21) syn_p0_n3
XS_h2_10_22 (vp vn sl_h2_10 h1_22) syn_p2_n0
XS_h2_10_23 (vp vn sl_h2_10 h1_23) syn_p1_n0
XS_h2_10_24 (vp vn sl_h2_10 h1_24) syn_p0_n2
XS_h2_10_25 (vp vn sl_h2_10 h1_25) syn_p3_n0
XS_h2_10_26 (vp vn sl_h2_10 h1_26) syn_p3_n1
XS_h2_10_27 (vp vn sl_h2_10 h1_27) syn_p1_n0
XS_h2_10_28 (vp vn sl_h2_10 h1_28) syn_p0_n2
XS_h2_10_29 (vp vn sl_h2_10 h1_29) syn_p1_n3
XS_h2_10_30 (vp vn sl_h2_10 h1_30) syn_p0_n1
XS_h2_10_31 (vp vn sl_h2_10 h1_31) syn_p1_n0
XS_h2_10_32 (vp vn sl_h2_10 h1_32) syn_p0_n2
XS_h2_10_33 (vp vn sl_h2_10 h1_33) syn_p3_n3
XS_h2_10_34 (vp vn sl_h2_10 h1_34) syn_p3_n3
XS_h2_10_35 (vp vn sl_h2_10 h1_35) syn_p0_n3
XS_h2_10_36 (vp vn sl_h2_10 h1_36) syn_p3_n3
XS_h2_10_37 (vp vn sl_h2_10 h1_37) syn_p1_n0
XS_h2_10_38 (vp vn sl_h2_10 h1_38) syn_p0_n2
XS_h2_10_39 (vp vn sl_h2_10 h1_39) syn_p2_n0
XS_h2_10_40 (vp vn sl_h2_10 h1_40) syn_p1_n0
XS_h2_10_41 (vp vn sl_h2_10 h1_41) syn_p3_n3
XS_h2_10_42 (vp vn sl_h2_10 h1_42) syn_p0_n1
XS_h2_10_43 (vp vn sl_h2_10 h1_43) syn_p3_n3
XS_h2_10_44 (vp vn sl_h2_10 h1_44) syn_p0_n1
XS_h2_10_45 (vp vn sl_h2_10 h1_45) syn_p3_n3
XS_h2_10_46 (vp vn sl_h2_10 h1_46) syn_p2_n0
XS_h2_10_47 (vp vn sl_h2_10 h1_47) syn_p0_n3
XS_h2_10_48 (vp vn sl_h2_10 h1_48) syn_p3_n3
XS_h2_10_49 (vp vn sl_h2_10 h1_49) syn_p3_n3
XS_h2_10_50 (vp vn sl_h2_10 h1_50) syn_p3_n1
XS_h2_10_51 (vp vn sl_h2_10 h1_51) syn_p0_n3
XS_h2_10_52 (vp vn sl_h2_10 h1_52) syn_p3_n3
XS_h2_10_53 (vp vn sl_h2_10 h1_53) syn_p1_n0
XS_h2_10_54 (vp vn sl_h2_10 h1_54) syn_p0_n2
XS_h2_10_55 (vp vn sl_h2_10 h1_55) syn_p1_n0
XS_h2_10_56 (vp vn sl_h2_10 h1_56) syn_p0_n2
XS_h2_10_57 (vp vn sl_h2_10 h1_57) syn_p3_n3
XS_h2_10_58 (vp vn sl_h2_10 h1_58) syn_p0_n1
XS_h2_10_59 (vp vn sl_h2_10 h1_59) syn_p0_n1
XS_h2_10_60 (vp vn sl_h2_10 h1_60) syn_p0_n1
XS_h2_10_61 (vp vn sl_h2_10 h1_61) syn_p3_n1
XS_h2_10_62 (vp vn sl_h2_10 h1_62) syn_p1_n0
XS_h2_10_63 (vp vn sl_h2_10 h1_63) syn_p3_n3
XS_h2_11_0 (vp vn sl_h2_11 h1_0) syn_p0_n1
XS_h2_11_1 (vp vn sl_h2_11 h1_1) syn_p0_n1
XS_h2_11_2 (vp vn sl_h2_11 h1_2) syn_p0_n1
XS_h2_11_3 (vp vn sl_h2_11 h1_3) syn_p3_n1
XS_h2_11_4 (vp vn sl_h2_11 h1_4) syn_p0_n1
XS_h2_11_5 (vp vn sl_h2_11 h1_5) syn_p0_n2
XS_h2_11_6 (vp vn sl_h2_11 h1_6) syn_p0_n1
XS_h2_11_7 (vp vn sl_h2_11 h1_7) syn_p2_n0
XS_h2_11_8 (vp vn sl_h2_11 h1_8) syn_p3_n3
XS_h2_11_9 (vp vn sl_h2_11 h1_9) syn_p2_n0
XS_h2_11_10 (vp vn sl_h2_11 h1_10) syn_p1_n0
XS_h2_11_11 (vp vn sl_h2_11 h1_11) syn_p3_n0
XS_h2_11_12 (vp vn sl_h2_11 h1_12) syn_p3_n0
XS_h2_11_13 (vp vn sl_h2_11 h1_13) syn_p0_n2
XS_h2_11_14 (vp vn sl_h2_11 h1_14) syn_p1_n3
XS_h2_11_15 (vp vn sl_h2_11 h1_15) syn_p3_n1
XS_h2_11_16 (vp vn sl_h2_11 h1_16) syn_p2_n0
XS_h2_11_17 (vp vn sl_h2_11 h1_17) syn_p0_n1
XS_h2_11_18 (vp vn sl_h2_11 h1_18) syn_p0_n1
XS_h2_11_19 (vp vn sl_h2_11 h1_19) syn_p0_n1
XS_h2_11_20 (vp vn sl_h2_11 h1_20) syn_p1_n3
XS_h2_11_21 (vp vn sl_h2_11 h1_21) syn_p0_n1
XS_h2_11_22 (vp vn sl_h2_11 h1_22) syn_p3_n3
XS_h2_11_23 (vp vn sl_h2_11 h1_23) syn_p0_n1
XS_h2_11_24 (vp vn sl_h2_11 h1_24) syn_p0_n1
XS_h2_11_25 (vp vn sl_h2_11 h1_25) syn_p3_n3
XS_h2_11_26 (vp vn sl_h2_11 h1_26) syn_p3_n3
XS_h2_11_27 (vp vn sl_h2_11 h1_27) syn_p3_n3
XS_h2_11_28 (vp vn sl_h2_11 h1_28) syn_p0_n2
XS_h2_11_29 (vp vn sl_h2_11 h1_29) syn_p3_n1
XS_h2_11_30 (vp vn sl_h2_11 h1_30) syn_p0_n1
XS_h2_11_31 (vp vn sl_h2_11 h1_31) syn_p2_n0
XS_h2_11_32 (vp vn sl_h2_11 h1_32) syn_p0_n1
XS_h2_11_33 (vp vn sl_h2_11 h1_33) syn_p0_n1
XS_h2_11_34 (vp vn sl_h2_11 h1_34) syn_p0_n1
XS_h2_11_35 (vp vn sl_h2_11 h1_35) syn_p1_n0
XS_h2_11_36 (vp vn sl_h2_11 h1_36) syn_p2_n0
XS_h2_11_37 (vp vn sl_h2_11 h1_37) syn_p2_n0
XS_h2_11_38 (vp vn sl_h2_11 h1_38) syn_p0_n1
XS_h2_11_39 (vp vn sl_h2_11 h1_39) syn_p1_n3
XS_h2_11_40 (vp vn sl_h2_11 h1_40) syn_p0_n2
XS_h2_11_41 (vp vn sl_h2_11 h1_41) syn_p3_n3
XS_h2_11_42 (vp vn sl_h2_11 h1_42) syn_p0_n1
XS_h2_11_43 (vp vn sl_h2_11 h1_43) syn_p2_n0
XS_h2_11_44 (vp vn sl_h2_11 h1_44) syn_p2_n0
XS_h2_11_45 (vp vn sl_h2_11 h1_45) syn_p0_n1
XS_h2_11_46 (vp vn sl_h2_11 h1_46) syn_p0_n2
XS_h2_11_47 (vp vn sl_h2_11 h1_47) syn_p3_n3
XS_h2_11_48 (vp vn sl_h2_11 h1_48) syn_p3_n3
XS_h2_11_49 (vp vn sl_h2_11 h1_49) syn_p0_n1
XS_h2_11_50 (vp vn sl_h2_11 h1_50) syn_p3_n3
XS_h2_11_51 (vp vn sl_h2_11 h1_51) syn_p3_n3
XS_h2_11_52 (vp vn sl_h2_11 h1_52) syn_p3_n3
XS_h2_11_53 (vp vn sl_h2_11 h1_53) syn_p1_n0
XS_h2_11_54 (vp vn sl_h2_11 h1_54) syn_p3_n3
XS_h2_11_55 (vp vn sl_h2_11 h1_55) syn_p1_n3
XS_h2_11_56 (vp vn sl_h2_11 h1_56) syn_p1_n0
XS_h2_11_57 (vp vn sl_h2_11 h1_57) syn_p0_n1
XS_h2_11_58 (vp vn sl_h2_11 h1_58) syn_p3_n3
XS_h2_11_59 (vp vn sl_h2_11 h1_59) syn_p3_n3
XS_h2_11_60 (vp vn sl_h2_11 h1_60) syn_p1_n0
XS_h2_11_61 (vp vn sl_h2_11 h1_61) syn_p3_n3
XS_h2_11_62 (vp vn sl_h2_11 h1_62) syn_p2_n0
XS_h2_11_63 (vp vn sl_h2_11 h1_63) syn_p3_n3
XS_h2_12_0 (vp vn sl_h2_12 h1_0) syn_p3_n1
XS_h2_12_1 (vp vn sl_h2_12 h1_1) syn_p2_n0
XS_h2_12_2 (vp vn sl_h2_12 h1_2) syn_p3_n0
XS_h2_12_3 (vp vn sl_h2_12 h1_3) syn_p0_n1
XS_h2_12_4 (vp vn sl_h2_12 h1_4) syn_p0_n2
XS_h2_12_5 (vp vn sl_h2_12 h1_5) syn_p0_n2
XS_h2_12_6 (vp vn sl_h2_12 h1_6) syn_p0_n2
XS_h2_12_7 (vp vn sl_h2_12 h1_7) syn_p0_n1
XS_h2_12_8 (vp vn sl_h2_12 h1_8) syn_p1_n0
XS_h2_12_9 (vp vn sl_h2_12 h1_9) syn_p0_n2
XS_h2_12_10 (vp vn sl_h2_12 h1_10) syn_p0_n1
XS_h2_12_11 (vp vn sl_h2_12 h1_11) syn_p0_n2
XS_h2_12_12 (vp vn sl_h2_12 h1_12) syn_p0_n2
XS_h2_12_13 (vp vn sl_h2_12 h1_13) syn_p0_n2
XS_h2_12_14 (vp vn sl_h2_12 h1_14) syn_p3_n1
XS_h2_12_15 (vp vn sl_h2_12 h1_15) syn_p3_n3
XS_h2_12_16 (vp vn sl_h2_12 h1_16) syn_p2_n0
XS_h2_12_17 (vp vn sl_h2_12 h1_17) syn_p1_n3
XS_h2_12_18 (vp vn sl_h2_12 h1_18) syn_p1_n0
XS_h2_12_19 (vp vn sl_h2_12 h1_19) syn_p3_n3
XS_h2_12_20 (vp vn sl_h2_12 h1_20) syn_p0_n2
XS_h2_12_21 (vp vn sl_h2_12 h1_21) syn_p3_n3
XS_h2_12_22 (vp vn sl_h2_12 h1_22) syn_p1_n3
XS_h2_12_23 (vp vn sl_h2_12 h1_23) syn_p3_n3
XS_h2_12_24 (vp vn sl_h2_12 h1_24) syn_p1_n0
XS_h2_12_25 (vp vn sl_h2_12 h1_25) syn_p3_n1
XS_h2_12_26 (vp vn sl_h2_12 h1_26) syn_p0_n3
XS_h2_12_27 (vp vn sl_h2_12 h1_27) syn_p0_n2
XS_h2_12_28 (vp vn sl_h2_12 h1_28) syn_p0_n1
XS_h2_12_29 (vp vn sl_h2_12 h1_29) syn_p0_n2
XS_h2_12_30 (vp vn sl_h2_12 h1_30) syn_p0_n1
XS_h2_12_31 (vp vn sl_h2_12 h1_31) syn_p1_n3
XS_h2_12_32 (vp vn sl_h2_12 h1_32) syn_p3_n1
XS_h2_12_33 (vp vn sl_h2_12 h1_33) syn_p2_n0
XS_h2_12_34 (vp vn sl_h2_12 h1_34) syn_p3_n3
XS_h2_12_35 (vp vn sl_h2_12 h1_35) syn_p0_n1
XS_h2_12_36 (vp vn sl_h2_12 h1_36) syn_p1_n3
XS_h2_12_37 (vp vn sl_h2_12 h1_37) syn_p0_n2
XS_h2_12_38 (vp vn sl_h2_12 h1_38) syn_p3_n3
XS_h2_12_39 (vp vn sl_h2_12 h1_39) syn_p2_n0
XS_h2_12_40 (vp vn sl_h2_12 h1_40) syn_p0_n2
XS_h2_12_41 (vp vn sl_h2_12 h1_41) syn_p3_n3
XS_h2_12_42 (vp vn sl_h2_12 h1_42) syn_p1_n0
XS_h2_12_43 (vp vn sl_h2_12 h1_43) syn_p0_n1
XS_h2_12_44 (vp vn sl_h2_12 h1_44) syn_p1_n0
XS_h2_12_45 (vp vn sl_h2_12 h1_45) syn_p0_n1
XS_h2_12_46 (vp vn sl_h2_12 h1_46) syn_p3_n3
XS_h2_12_47 (vp vn sl_h2_12 h1_47) syn_p0_n2
XS_h2_12_48 (vp vn sl_h2_12 h1_48) syn_p0_n1
XS_h2_12_49 (vp vn sl_h2_12 h1_49) syn_p0_n3
XS_h2_12_50 (vp vn sl_h2_12 h1_50) syn_p0_n1
XS_h2_12_51 (vp vn sl_h2_12 h1_51) syn_p3_n3
XS_h2_12_52 (vp vn sl_h2_12 h1_52) syn_p3_n1
XS_h2_12_53 (vp vn sl_h2_12 h1_53) syn_p0_n3
XS_h2_12_54 (vp vn sl_h2_12 h1_54) syn_p3_n3
XS_h2_12_55 (vp vn sl_h2_12 h1_55) syn_p1_n0
XS_h2_12_56 (vp vn sl_h2_12 h1_56) syn_p3_n3
XS_h2_12_57 (vp vn sl_h2_12 h1_57) syn_p3_n3
XS_h2_12_58 (vp vn sl_h2_12 h1_58) syn_p3_n3
XS_h2_12_59 (vp vn sl_h2_12 h1_59) syn_p0_n2
XS_h2_12_60 (vp vn sl_h2_12 h1_60) syn_p1_n0
XS_h2_12_61 (vp vn sl_h2_12 h1_61) syn_p0_n2
XS_h2_12_62 (vp vn sl_h2_12 h1_62) syn_p1_n0
XS_h2_12_63 (vp vn sl_h2_12 h1_63) syn_p1_n3
XS_h2_13_0 (vp vn sl_h2_13 h1_0) syn_p0_n2
XS_h2_13_1 (vp vn sl_h2_13 h1_1) syn_p0_n1
XS_h2_13_2 (vp vn sl_h2_13 h1_2) syn_p2_n0
XS_h2_13_3 (vp vn sl_h2_13 h1_3) syn_p1_n0
XS_h2_13_4 (vp vn sl_h2_13 h1_4) syn_p3_n3
XS_h2_13_5 (vp vn sl_h2_13 h1_5) syn_p1_n0
XS_h2_13_6 (vp vn sl_h2_13 h1_6) syn_p3_n3
XS_h2_13_7 (vp vn sl_h2_13 h1_7) syn_p0_n1
XS_h2_13_8 (vp vn sl_h2_13 h1_8) syn_p1_n0
XS_h2_13_9 (vp vn sl_h2_13 h1_9) syn_p3_n3
XS_h2_13_10 (vp vn sl_h2_13 h1_10) syn_p0_n2
XS_h2_13_11 (vp vn sl_h2_13 h1_11) syn_p0_n2
XS_h2_13_12 (vp vn sl_h2_13 h1_12) syn_p0_n1
XS_h2_13_13 (vp vn sl_h2_13 h1_13) syn_p3_n3
XS_h2_13_14 (vp vn sl_h2_13 h1_14) syn_p0_n2
XS_h2_13_15 (vp vn sl_h2_13 h1_15) syn_p3_n3
XS_h2_13_16 (vp vn sl_h2_13 h1_16) syn_p0_n2
XS_h2_13_17 (vp vn sl_h2_13 h1_17) syn_p3_n1
XS_h2_13_18 (vp vn sl_h2_13 h1_18) syn_p3_n3
XS_h2_13_19 (vp vn sl_h2_13 h1_19) syn_p0_n1
XS_h2_13_20 (vp vn sl_h2_13 h1_20) syn_p1_n0
XS_h2_13_21 (vp vn sl_h2_13 h1_21) syn_p1_n0
XS_h2_13_22 (vp vn sl_h2_13 h1_22) syn_p3_n1
XS_h2_13_23 (vp vn sl_h2_13 h1_23) syn_p1_n0
XS_h2_13_24 (vp vn sl_h2_13 h1_24) syn_p3_n3
XS_h2_13_25 (vp vn sl_h2_13 h1_25) syn_p3_n1
XS_h2_13_26 (vp vn sl_h2_13 h1_26) syn_p2_n0
XS_h2_13_27 (vp vn sl_h2_13 h1_27) syn_p0_n3
XS_h2_13_28 (vp vn sl_h2_13 h1_28) syn_p1_n0
XS_h2_13_29 (vp vn sl_h2_13 h1_29) syn_p0_n1
XS_h2_13_30 (vp vn sl_h2_13 h1_30) syn_p0_n2
XS_h2_13_31 (vp vn sl_h2_13 h1_31) syn_p0_n1
XS_h2_13_32 (vp vn sl_h2_13 h1_32) syn_p1_n0
XS_h2_13_33 (vp vn sl_h2_13 h1_33) syn_p3_n3
XS_h2_13_34 (vp vn sl_h2_13 h1_34) syn_p0_n1
XS_h2_13_35 (vp vn sl_h2_13 h1_35) syn_p0_n1
XS_h2_13_36 (vp vn sl_h2_13 h1_36) syn_p2_n0
XS_h2_13_37 (vp vn sl_h2_13 h1_37) syn_p0_n2
XS_h2_13_38 (vp vn sl_h2_13 h1_38) syn_p3_n3
XS_h2_13_39 (vp vn sl_h2_13 h1_39) syn_p3_n3
XS_h2_13_40 (vp vn sl_h2_13 h1_40) syn_p0_n2
XS_h2_13_41 (vp vn sl_h2_13 h1_41) syn_p3_n3
XS_h2_13_42 (vp vn sl_h2_13 h1_42) syn_p0_n2
XS_h2_13_43 (vp vn sl_h2_13 h1_43) syn_p0_n2
XS_h2_13_44 (vp vn sl_h2_13 h1_44) syn_p3_n1
XS_h2_13_45 (vp vn sl_h2_13 h1_45) syn_p0_n1
XS_h2_13_46 (vp vn sl_h2_13 h1_46) syn_p0_n1
XS_h2_13_47 (vp vn sl_h2_13 h1_47) syn_p3_n3
XS_h2_13_48 (vp vn sl_h2_13 h1_48) syn_p3_n3
XS_h2_13_49 (vp vn sl_h2_13 h1_49) syn_p1_n0
XS_h2_13_50 (vp vn sl_h2_13 h1_50) syn_p0_n3
XS_h2_13_51 (vp vn sl_h2_13 h1_51) syn_p0_n1
XS_h2_13_52 (vp vn sl_h2_13 h1_52) syn_p3_n1
XS_h2_13_53 (vp vn sl_h2_13 h1_53) syn_p0_n1
XS_h2_13_54 (vp vn sl_h2_13 h1_54) syn_p1_n3
XS_h2_13_55 (vp vn sl_h2_13 h1_55) syn_p3_n3
XS_h2_13_56 (vp vn sl_h2_13 h1_56) syn_p0_n2
XS_h2_13_57 (vp vn sl_h2_13 h1_57) syn_p3_n3
XS_h2_13_58 (vp vn sl_h2_13 h1_58) syn_p3_n3
XS_h2_13_59 (vp vn sl_h2_13 h1_59) syn_p2_n0
XS_h2_13_60 (vp vn sl_h2_13 h1_60) syn_p0_n2
XS_h2_13_61 (vp vn sl_h2_13 h1_61) syn_p3_n3
XS_h2_13_62 (vp vn sl_h2_13 h1_62) syn_p2_n0
XS_h2_13_63 (vp vn sl_h2_13 h1_63) syn_p1_n0
XS_h2_14_0 (vp vn sl_h2_14 h1_0) syn_p2_n0
XS_h2_14_1 (vp vn sl_h2_14 h1_1) syn_p2_n0
XS_h2_14_2 (vp vn sl_h2_14 h1_2) syn_p0_n1
XS_h2_14_3 (vp vn sl_h2_14 h1_3) syn_p3_n0
XS_h2_14_4 (vp vn sl_h2_14 h1_4) syn_p3_n1
XS_h2_14_5 (vp vn sl_h2_14 h1_5) syn_p0_n2
XS_h2_14_6 (vp vn sl_h2_14 h1_6) syn_p1_n0
XS_h2_14_7 (vp vn sl_h2_14 h1_7) syn_p0_n1
XS_h2_14_8 (vp vn sl_h2_14 h1_8) syn_p3_n3
XS_h2_14_9 (vp vn sl_h2_14 h1_9) syn_p0_n3
XS_h2_14_10 (vp vn sl_h2_14 h1_10) syn_p3_n1
XS_h2_14_11 (vp vn sl_h2_14 h1_11) syn_p2_n0
XS_h2_14_12 (vp vn sl_h2_14 h1_12) syn_p2_n0
XS_h2_14_13 (vp vn sl_h2_14 h1_13) syn_p1_n3
XS_h2_14_14 (vp vn sl_h2_14 h1_14) syn_p1_n3
XS_h2_14_15 (vp vn sl_h2_14 h1_15) syn_p3_n3
XS_h2_14_16 (vp vn sl_h2_14 h1_16) syn_p0_n2
XS_h2_14_17 (vp vn sl_h2_14 h1_17) syn_p2_n0
XS_h2_14_18 (vp vn sl_h2_14 h1_18) syn_p3_n3
XS_h2_14_19 (vp vn sl_h2_14 h1_19) syn_p0_n1
XS_h2_14_20 (vp vn sl_h2_14 h1_20) syn_p1_n0
XS_h2_14_21 (vp vn sl_h2_14 h1_21) syn_p1_n3
XS_h2_14_22 (vp vn sl_h2_14 h1_22) syn_p1_n3
XS_h2_14_23 (vp vn sl_h2_14 h1_23) syn_p0_n1
XS_h2_14_24 (vp vn sl_h2_14 h1_24) syn_p3_n3
XS_h2_14_25 (vp vn sl_h2_14 h1_25) syn_p0_n3
XS_h2_14_26 (vp vn sl_h2_14 h1_26) syn_p1_n0
XS_h2_14_27 (vp vn sl_h2_14 h1_27) syn_p0_n2
XS_h2_14_28 (vp vn sl_h2_14 h1_28) syn_p1_n0
XS_h2_14_29 (vp vn sl_h2_14 h1_29) syn_p3_n3
XS_h2_14_30 (vp vn sl_h2_14 h1_30) syn_p0_n1
XS_h2_14_31 (vp vn sl_h2_14 h1_31) syn_p1_n3
XS_h2_14_32 (vp vn sl_h2_14 h1_32) syn_p1_n0
XS_h2_14_33 (vp vn sl_h2_14 h1_33) syn_p1_n0
XS_h2_14_34 (vp vn sl_h2_14 h1_34) syn_p1_n0
XS_h2_14_35 (vp vn sl_h2_14 h1_35) syn_p0_n1
XS_h2_14_36 (vp vn sl_h2_14 h1_36) syn_p3_n1
XS_h2_14_37 (vp vn sl_h2_14 h1_37) syn_p0_n3
XS_h2_14_38 (vp vn sl_h2_14 h1_38) syn_p1_n0
XS_h2_14_39 (vp vn sl_h2_14 h1_39) syn_p2_n0
XS_h2_14_40 (vp vn sl_h2_14 h1_40) syn_p0_n1
XS_h2_14_41 (vp vn sl_h2_14 h1_41) syn_p0_n2
XS_h2_14_42 (vp vn sl_h2_14 h1_42) syn_p1_n0
XS_h2_14_43 (vp vn sl_h2_14 h1_43) syn_p2_n0
XS_h2_14_44 (vp vn sl_h2_14 h1_44) syn_p0_n2
XS_h2_14_45 (vp vn sl_h2_14 h1_45) syn_p0_n3
XS_h2_14_46 (vp vn sl_h2_14 h1_46) syn_p2_n0
XS_h2_14_47 (vp vn sl_h2_14 h1_47) syn_p1_n3
XS_h2_14_48 (vp vn sl_h2_14 h1_48) syn_p2_n0
XS_h2_14_49 (vp vn sl_h2_14 h1_49) syn_p2_n0
XS_h2_14_50 (vp vn sl_h2_14 h1_50) syn_p3_n3
XS_h2_14_51 (vp vn sl_h2_14 h1_51) syn_p3_n3
XS_h2_14_52 (vp vn sl_h2_14 h1_52) syn_p3_n3
XS_h2_14_53 (vp vn sl_h2_14 h1_53) syn_p2_n0
XS_h2_14_54 (vp vn sl_h2_14 h1_54) syn_p0_n1
XS_h2_14_55 (vp vn sl_h2_14 h1_55) syn_p1_n0
XS_h2_14_56 (vp vn sl_h2_14 h1_56) syn_p0_n1
XS_h2_14_57 (vp vn sl_h2_14 h1_57) syn_p0_n2
XS_h2_14_58 (vp vn sl_h2_14 h1_58) syn_p2_n0
XS_h2_14_59 (vp vn sl_h2_14 h1_59) syn_p0_n1
XS_h2_14_60 (vp vn sl_h2_14 h1_60) syn_p0_n1
XS_h2_14_61 (vp vn sl_h2_14 h1_61) syn_p3_n1
XS_h2_14_62 (vp vn sl_h2_14 h1_62) syn_p2_n0
XS_h2_14_63 (vp vn sl_h2_14 h1_63) syn_p3_n3
XS_h2_15_0 (vp vn sl_h2_15 h1_0) syn_p3_n3
XS_h2_15_1 (vp vn sl_h2_15 h1_1) syn_p0_n1
XS_h2_15_2 (vp vn sl_h2_15 h1_2) syn_p3_n0
XS_h2_15_3 (vp vn sl_h2_15 h1_3) syn_p3_n0
XS_h2_15_4 (vp vn sl_h2_15 h1_4) syn_p0_n1
XS_h2_15_5 (vp vn sl_h2_15 h1_5) syn_p3_n3
XS_h2_15_6 (vp vn sl_h2_15 h1_6) syn_p0_n2
XS_h2_15_7 (vp vn sl_h2_15 h1_7) syn_p3_n3
XS_h2_15_8 (vp vn sl_h2_15 h1_8) syn_p0_n1
XS_h2_15_9 (vp vn sl_h2_15 h1_9) syn_p3_n3
XS_h2_15_10 (vp vn sl_h2_15 h1_10) syn_p0_n2
XS_h2_15_11 (vp vn sl_h2_15 h1_11) syn_p0_n1
XS_h2_15_12 (vp vn sl_h2_15 h1_12) syn_p0_n1
XS_h2_15_13 (vp vn sl_h2_15 h1_13) syn_p0_n1
XS_h2_15_14 (vp vn sl_h2_15 h1_14) syn_p1_n0
XS_h2_15_15 (vp vn sl_h2_15 h1_15) syn_p0_n2
XS_h2_15_16 (vp vn sl_h2_15 h1_16) syn_p1_n0
XS_h2_15_17 (vp vn sl_h2_15 h1_17) syn_p0_n2
XS_h2_15_18 (vp vn sl_h2_15 h1_18) syn_p0_n1
XS_h2_15_19 (vp vn sl_h2_15 h1_19) syn_p1_n3
XS_h2_15_20 (vp vn sl_h2_15 h1_20) syn_p0_n2
XS_h2_15_21 (vp vn sl_h2_15 h1_21) syn_p3_n3
XS_h2_15_22 (vp vn sl_h2_15 h1_22) syn_p3_n1
XS_h2_15_23 (vp vn sl_h2_15 h1_23) syn_p1_n3
XS_h2_15_24 (vp vn sl_h2_15 h1_24) syn_p3_n0
XS_h2_15_25 (vp vn sl_h2_15 h1_25) syn_p0_n1
XS_h2_15_26 (vp vn sl_h2_15 h1_26) syn_p3_n0
XS_h2_15_27 (vp vn sl_h2_15 h1_27) syn_p0_n1
XS_h2_15_28 (vp vn sl_h2_15 h1_28) syn_p3_n3
XS_h2_15_29 (vp vn sl_h2_15 h1_29) syn_p2_n0
XS_h2_15_30 (vp vn sl_h2_15 h1_30) syn_p3_n3
XS_h2_15_31 (vp vn sl_h2_15 h1_31) syn_p0_n1
XS_h2_15_32 (vp vn sl_h2_15 h1_32) syn_p3_n1
XS_h2_15_33 (vp vn sl_h2_15 h1_33) syn_p3_n0
XS_h2_15_34 (vp vn sl_h2_15 h1_34) syn_p3_n0
XS_h2_15_35 (vp vn sl_h2_15 h1_35) syn_p1_n0
XS_h2_15_36 (vp vn sl_h2_15 h1_36) syn_p1_n3
XS_h2_15_37 (vp vn sl_h2_15 h1_37) syn_p0_n2
XS_h2_15_38 (vp vn sl_h2_15 h1_38) syn_p2_n0
XS_h2_15_39 (vp vn sl_h2_15 h1_39) syn_p0_n2
XS_h2_15_40 (vp vn sl_h2_15 h1_40) syn_p3_n0
XS_h2_15_41 (vp vn sl_h2_15 h1_41) syn_p0_n2
XS_h2_15_42 (vp vn sl_h2_15 h1_42) syn_p3_n3
XS_h2_15_43 (vp vn sl_h2_15 h1_43) syn_p2_n0
XS_h2_15_44 (vp vn sl_h2_15 h1_44) syn_p3_n3
XS_h2_15_45 (vp vn sl_h2_15 h1_45) syn_p0_n1
XS_h2_15_46 (vp vn sl_h2_15 h1_46) syn_p0_n2
XS_h2_15_47 (vp vn sl_h2_15 h1_47) syn_p2_n0
XS_h2_15_48 (vp vn sl_h2_15 h1_48) syn_p3_n1
XS_h2_15_49 (vp vn sl_h2_15 h1_49) syn_p0_n1
XS_h2_15_50 (vp vn sl_h2_15 h1_50) syn_p0_n2
XS_h2_15_51 (vp vn sl_h2_15 h1_51) syn_p0_n1
XS_h2_15_52 (vp vn sl_h2_15 h1_52) syn_p2_n0
XS_h2_15_53 (vp vn sl_h2_15 h1_53) syn_p0_n1
XS_h2_15_54 (vp vn sl_h2_15 h1_54) syn_p1_n3
XS_h2_15_55 (vp vn sl_h2_15 h1_55) syn_p0_n1
XS_h2_15_56 (vp vn sl_h2_15 h1_56) syn_p0_n1
XS_h2_15_57 (vp vn sl_h2_15 h1_57) syn_p3_n3
XS_h2_15_58 (vp vn sl_h2_15 h1_58) syn_p1_n3
XS_h2_15_59 (vp vn sl_h2_15 h1_59) syn_p3_n1
XS_h2_15_60 (vp vn sl_h2_15 h1_60) syn_p0_n2
XS_h2_15_61 (vp vn sl_h2_15 h1_61) syn_p3_n1
XS_h2_15_62 (vp vn sl_h2_15 h1_62) syn_p3_n3
XS_h2_15_63 (vp vn sl_h2_15 h1_63) syn_p1_n0
XN_h2_0 (sl_h2_0 h2_0 clk qclk vref vres vth) neuron_h2
XN_h2_1 (sl_h2_1 h2_1 clk qclk vref vres vth) neuron_h2
XN_h2_2 (sl_h2_2 h2_2 clk qclk vref vres vth) neuron_h2
XN_h2_3 (sl_h2_3 h2_3 clk qclk vref vres vth) neuron_h2
XN_h2_4 (sl_h2_4 h2_4 clk qclk vref vres vth) neuron_h2
XN_h2_5 (sl_h2_5 h2_5 clk qclk vref vres vth) neuron_h2
XN_h2_6 (sl_h2_6 h2_6 clk qclk vref vres vth) neuron_h2
XN_h2_7 (sl_h2_7 h2_7 clk qclk vref vres vth) neuron_h2
XN_h2_8 (sl_h2_8 h2_8 clk qclk vref vres vth) neuron_h2
XN_h2_9 (sl_h2_9 h2_9 clk qclk vref vres vth) neuron_h2
XN_h2_10 (sl_h2_10 h2_10 clk qclk vref vres vth) neuron_h2
XN_h2_11 (sl_h2_11 h2_11 clk qclk vref vres vth) neuron_h2
XN_h2_12 (sl_h2_12 h2_12 clk qclk vref vres vth) neuron_h2
XN_h2_13 (sl_h2_13 h2_13 clk qclk vref vres vth) neuron_h2
XN_h2_14 (sl_h2_14 h2_14 clk qclk vref vres vth) neuron_h2
XN_h2_15 (sl_h2_15 h2_15 clk qclk vref vres vth) neuron_h2

opts2 options save=lvlpub nestlvl=1
tr tran stop=5e-07 step=5e-10 skipdc=yes
