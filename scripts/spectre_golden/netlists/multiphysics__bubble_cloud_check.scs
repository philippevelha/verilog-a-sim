// multiphysics__bubble_cloud_check -- Spectre translation of circuits/multiphysics/bubble_cloud_check.net (scripts/spectre_golden/net2spectre.py)
simulator lang=spectre
global 0
opts options reltol=1e-6 vabstol=1e-9 iabstol=1e-15 temp=27 tnom=27 gmin=1e-18 save=selected

ahdl_include "models/multiphysics/bubble/bubble_parts.va"

XD (pb) bubble_drive g=0.1 gdot=0 omega=0.25 nper=50
XB1 (p1) bubble alpha0=0.001 mu=0.05 tpoinc=25.1327412287 tskip=6.28318530718
XB2 (p2) bubble alpha0=0.001 mu=0.05 tpoinc=25.1327412287 tskip=6.28318530718
XB3 (p3) bubble alpha0=0.001 mu=0.05 tpoinc=25.1327412287 tskip=6.28318530718
XB4 (p4) bubble alpha0=0.001 mu=0.05 tpoinc=25.1327412287 tskip=6.28318530718
XB5 (p5) bubble alpha0=0.001 mu=0.05 tpoinc=25.1327412287 tskip=6.28318530718
XB6 (p6) bubble alpha0=0.001 mu=0.05 tpoinc=25.1327412287 tskip=6.28318530718
XB7 (p7) bubble alpha0=0.001 mu=0.05 tpoinc=25.1327412287 tskip=6.28318530718
XB8 (p8) bubble alpha0=0.001 mu=0.05 tpoinc=25.1327412287 tskip=6.28318530718
XB9 (p9) bubble alpha0=0.001 mu=0.05 tpoinc=25.1327412287 tskip=6.28318530718
XB10 (p10) bubble alpha0=0.001 mu=0.05 tpoinc=25.1327412287 tskip=6.28318530718
XB11 (p11) bubble alpha0=0.001 mu=0.05 tpoinc=25.1327412287 tskip=6.28318530718
XB12 (p12) bubble alpha0=0.001 mu=0.05 tpoinc=25.1327412287 tskip=6.28318530718
XB13 (p13) bubble alpha0=0.001 mu=0.05 tpoinc=25.1327412287 tskip=6.28318530718
XB14 (p14) bubble alpha0=0.001 mu=0.05 tpoinc=25.1327412287 tskip=6.28318530718
XB15 (p15) bubble alpha0=0.001 mu=0.05 tpoinc=25.1327412287 tskip=6.28318530718
XB16 (p16) bubble alpha0=0.001 mu=0.05 tpoinc=25.1327412287 tskip=6.28318530718
XB17 (p17) bubble alpha0=0.001 mu=0.05 tpoinc=25.1327412287 tskip=6.28318530718
XB18 (p18) bubble alpha0=0.001 mu=0.05 tpoinc=25.1327412287 tskip=6.28318530718
XB19 (p19) bubble alpha0=0.001 mu=0.05 tpoinc=25.1327412287 tskip=6.28318530718
XB20 (p20) bubble alpha0=0.001 mu=0.05 tpoinc=25.1327412287 tskip=6.28318530718
XB21 (p21) bubble alpha0=0.001 mu=0.05 tpoinc=25.1327412287 tskip=6.28318530718
XB22 (p22) bubble alpha0=0.001 mu=0.05 tpoinc=25.1327412287 tskip=6.28318530718
XB23 (p23) bubble alpha0=0.001 mu=0.05 tpoinc=25.1327412287 tskip=6.28318530718
XB24 (p24) bubble alpha0=0.001 mu=0.05 tpoinc=25.1327412287 tskip=6.28318530718
XB25 (p25) bubble alpha0=0.001 mu=0.05 tpoinc=25.1327412287 tskip=6.28318530718
XB26 (p26) bubble alpha0=0.001 mu=0.05 tpoinc=25.1327412287 tskip=6.28318530718
XB27 (p27) bubble alpha0=0.001 mu=0.05 tpoinc=25.1327412287 tskip=6.28318530718
XB28 (p28) bubble alpha0=0.001 mu=0.05 tpoinc=25.1327412287 tskip=6.28318530718
XB29 (p29) bubble alpha0=0.001 mu=0.05 tpoinc=25.1327412287 tskip=6.28318530718
XB30 (p30) bubble alpha0=0.001 mu=0.05 tpoinc=25.1327412287 tskip=6.28318530718
XB31 (p31) bubble alpha0=0.001 mu=0.05 tpoinc=25.1327412287 tskip=6.28318530718
XB32 (p32) bubble alpha0=0.001 mu=0.05 tpoinc=25.1327412287 tskip=6.28318530718
XB33 (p33) bubble alpha0=0.001 mu=0.05 tpoinc=25.1327412287 tskip=6.28318530718
XB34 (p34) bubble alpha0=0.001 mu=0.05 tpoinc=25.1327412287 tskip=6.28318530718
XB35 (p35) bubble alpha0=0.001 mu=0.05 tpoinc=25.1327412287 tskip=6.28318530718
XB36 (p36) bubble alpha0=0.001 mu=0.05 tpoinc=25.1327412287 tskip=6.28318530718
XB37 (p37) bubble alpha0=0.001 mu=0.05 tpoinc=25.1327412287 tskip=6.28318530718
XB38 (p38) bubble alpha0=0.001 mu=0.05 tpoinc=25.1327412287 tskip=6.28318530718
XB39 (p39) bubble alpha0=0.001 mu=0.05 tpoinc=25.1327412287 tskip=6.28318530718
XB40 (p40) bubble alpha0=0.001 mu=0.05 tpoinc=25.1327412287 tskip=6.28318530718
XB41 (p41) bubble alpha0=0.001 mu=0.05 tpoinc=25.1327412287 tskip=6.28318530718
XB42 (p42) bubble alpha0=0.001 mu=0.05 tpoinc=25.1327412287 tskip=6.28318530718
XB43 (p43) bubble alpha0=0.001 mu=0.05 tpoinc=25.1327412287 tskip=6.28318530718
XB44 (p44) bubble alpha0=0.001 mu=0.05 tpoinc=25.1327412287 tskip=6.28318530718
XB45 (p45) bubble alpha0=0.001 mu=0.05 tpoinc=25.1327412287 tskip=6.28318530718
XB46 (p46) bubble alpha0=0.001 mu=0.05 tpoinc=25.1327412287 tskip=6.28318530718
XB47 (p47) bubble alpha0=0.001 mu=0.05 tpoinc=25.1327412287 tskip=6.28318530718
XB48 (p48) bubble alpha0=0.001 mu=0.05 tpoinc=25.1327412287 tskip=6.28318530718
XB49 (p49) bubble alpha0=0.001 mu=0.05 tpoinc=25.1327412287 tskip=6.28318530718
XB50 (p50) bubble alpha0=0.001 mu=0.05 tpoinc=25.1327412287 tskip=6.28318530718
XB51 (p51) bubble alpha0=0.001 mu=0.05 tpoinc=25.1327412287 tskip=6.28318530718
XB52 (p52) bubble alpha0=0.001 mu=0.05 tpoinc=25.1327412287 tskip=6.28318530718
XB53 (p53) bubble alpha0=0.001 mu=0.05 tpoinc=25.1327412287 tskip=6.28318530718
XB54 (p54) bubble alpha0=0.001 mu=0.05 tpoinc=25.1327412287 tskip=6.28318530718
XB55 (p55) bubble alpha0=0.001 mu=0.05 tpoinc=25.1327412287 tskip=6.28318530718
XB56 (p56) bubble alpha0=0.001 mu=0.05 tpoinc=25.1327412287 tskip=6.28318530718
XB57 (p57) bubble alpha0=0.001 mu=0.05 tpoinc=25.1327412287 tskip=6.28318530718
XB58 (p58) bubble alpha0=0.001 mu=0.05 tpoinc=25.1327412287 tskip=6.28318530718
XB59 (p59) bubble alpha0=0.001 mu=0.05 tpoinc=25.1327412287 tskip=6.28318530718
XB60 (p60) bubble alpha0=0.001 mu=0.05 tpoinc=25.1327412287 tskip=6.28318530718
XB61 (p61) bubble alpha0=0.001 mu=0.05 tpoinc=25.1327412287 tskip=6.28318530718
XB62 (p62) bubble alpha0=0.001 mu=0.05 tpoinc=25.1327412287 tskip=6.28318530718
XB63 (p63) bubble alpha0=0.001 mu=0.05 tpoinc=25.1327412287 tskip=6.28318530718
XB64 (p64) bubble alpha0=0.001 mu=0.05 tpoinc=25.1327412287 tskip=6.28318530718
XB65 (p65) bubble alpha0=0.001 mu=0.05 tpoinc=25.1327412287 tskip=6.28318530718
XB66 (p66) bubble alpha0=0.001 mu=0.05 tpoinc=25.1327412287 tskip=6.28318530718
XB67 (p67) bubble alpha0=0.001 mu=0.05 tpoinc=25.1327412287 tskip=6.28318530718
XB68 (p68) bubble alpha0=0.001 mu=0.05 tpoinc=25.1327412287 tskip=6.28318530718
XB69 (p69) bubble alpha0=0.001 mu=0.05 tpoinc=25.1327412287 tskip=6.28318530718
XB70 (p70) bubble alpha0=0.001 mu=0.05 tpoinc=25.1327412287 tskip=6.28318530718
XB71 (p71) bubble alpha0=0.001 mu=0.05 tpoinc=25.1327412287 tskip=6.28318530718
XB72 (p72) bubble alpha0=0.001 mu=0.05 tpoinc=25.1327412287 tskip=6.28318530718
XB73 (p73) bubble alpha0=0.001 mu=0.05 tpoinc=25.1327412287 tskip=6.28318530718
XB74 (p74) bubble alpha0=0.001 mu=0.05 tpoinc=25.1327412287 tskip=6.28318530718
XB75 (p75) bubble alpha0=0.001 mu=0.05 tpoinc=25.1327412287 tskip=6.28318530718
XB76 (p76) bubble alpha0=0.001 mu=0.05 tpoinc=25.1327412287 tskip=6.28318530718
XB77 (p77) bubble alpha0=0.001 mu=0.05 tpoinc=25.1327412287 tskip=6.28318530718
XB78 (p78) bubble alpha0=0.001 mu=0.05 tpoinc=25.1327412287 tskip=6.28318530718
XB79 (p79) bubble alpha0=0.001 mu=0.05 tpoinc=25.1327412287 tskip=6.28318530718
XB80 (p80) bubble alpha0=0.001 mu=0.05 tpoinc=25.1327412287 tskip=6.28318530718
XB81 (p81) bubble alpha0=0.001 mu=0.05 tpoinc=25.1327412287 tskip=6.28318530718
XB82 (p82) bubble alpha0=0.001 mu=0.05 tpoinc=25.1327412287 tskip=6.28318530718
XB83 (p83) bubble alpha0=0.001 mu=0.05 tpoinc=25.1327412287 tskip=6.28318530718
XB84 (p84) bubble alpha0=0.001 mu=0.05 tpoinc=25.1327412287 tskip=6.28318530718
XB85 (p85) bubble alpha0=0.001 mu=0.05 tpoinc=25.1327412287 tskip=6.28318530718
XB86 (p86) bubble alpha0=0.001 mu=0.05 tpoinc=25.1327412287 tskip=6.28318530718
XB87 (p87) bubble alpha0=0.001 mu=0.05 tpoinc=25.1327412287 tskip=6.28318530718
XB88 (p88) bubble alpha0=0.001 mu=0.05 tpoinc=25.1327412287 tskip=6.28318530718
XB89 (p89) bubble alpha0=0.001 mu=0.05 tpoinc=25.1327412287 tskip=6.28318530718
XB90 (p90) bubble alpha0=0.001 mu=0.05 tpoinc=25.1327412287 tskip=6.28318530718
XB91 (p91) bubble alpha0=0.001 mu=0.05 tpoinc=25.1327412287 tskip=6.28318530718
XB92 (p92) bubble alpha0=0.001 mu=0.05 tpoinc=25.1327412287 tskip=6.28318530718
XB93 (p93) bubble alpha0=0.001 mu=0.05 tpoinc=25.1327412287 tskip=6.28318530718
XB94 (p94) bubble alpha0=0.001 mu=0.05 tpoinc=25.1327412287 tskip=6.28318530718
XB95 (p95) bubble alpha0=0.001 mu=0.05 tpoinc=25.1327412287 tskip=6.28318530718
XB96 (p96) bubble alpha0=0.001 mu=0.05 tpoinc=25.1327412287 tskip=6.28318530718
XB97 (p97) bubble alpha0=0.001 mu=0.05 tpoinc=25.1327412287 tskip=6.28318530718
XB98 (p98) bubble alpha0=0.001 mu=0.05 tpoinc=25.1327412287 tskip=6.28318530718
XB99 (p99) bubble alpha0=0.001 mu=0.05 tpoinc=25.1327412287 tskip=6.28318530718
XB100 (p100) bubble alpha0=0.001 mu=0.05 tpoinc=25.1327412287 tskip=6.28318530718
XB101 (p101) bubble alpha0=0.001 mu=0.05 tpoinc=25.1327412287 tskip=6.28318530718
XB102 (p102) bubble alpha0=0.001 mu=0.05 tpoinc=25.1327412287 tskip=6.28318530718
XB103 (p103) bubble alpha0=0.001 mu=0.05 tpoinc=25.1327412287 tskip=6.28318530718
XB104 (p104) bubble alpha0=0.001 mu=0.05 tpoinc=25.1327412287 tskip=6.28318530718
XB105 (p105) bubble alpha0=0.001 mu=0.05 tpoinc=25.1327412287 tskip=6.28318530718
XB106 (p106) bubble alpha0=0.001 mu=0.05 tpoinc=25.1327412287 tskip=6.28318530718
XB107 (p107) bubble alpha0=0.001 mu=0.05 tpoinc=25.1327412287 tskip=6.28318530718
XB108 (p108) bubble alpha0=0.001 mu=0.05 tpoinc=25.1327412287 tskip=6.28318530718
XB109 (p109) bubble alpha0=0.001 mu=0.05 tpoinc=25.1327412287 tskip=6.28318530718
XB110 (p110) bubble alpha0=0.001 mu=0.05 tpoinc=25.1327412287 tskip=6.28318530718
XB111 (p111) bubble alpha0=0.001 mu=0.05 tpoinc=25.1327412287 tskip=6.28318530718
XB112 (p112) bubble alpha0=0.001 mu=0.05 tpoinc=25.1327412287 tskip=6.28318530718
XB113 (p113) bubble alpha0=0.001 mu=0.05 tpoinc=25.1327412287 tskip=6.28318530718
XB114 (p114) bubble alpha0=0.001 mu=0.05 tpoinc=25.1327412287 tskip=6.28318530718
XB115 (p115) bubble alpha0=0.001 mu=0.05 tpoinc=25.1327412287 tskip=6.28318530718
XB116 (p116) bubble alpha0=0.001 mu=0.05 tpoinc=25.1327412287 tskip=6.28318530718
XB117 (p117) bubble alpha0=0.001 mu=0.05 tpoinc=25.1327412287 tskip=6.28318530718
XB118 (p118) bubble alpha0=0.001 mu=0.05 tpoinc=25.1327412287 tskip=6.28318530718
XB119 (p119) bubble alpha0=0.001 mu=0.05 tpoinc=25.1327412287 tskip=6.28318530718
XB120 (p120) bubble alpha0=0.001 mu=0.05 tpoinc=25.1327412287 tskip=6.28318530718
XB121 (p121) bubble alpha0=0.001 mu=0.05 tpoinc=25.1327412287 tskip=6.28318530718
XB122 (p122) bubble alpha0=0.001 mu=0.05 tpoinc=25.1327412287 tskip=6.28318530718
XB123 (p123) bubble alpha0=0.001 mu=0.05 tpoinc=25.1327412287 tskip=6.28318530718
XB124 (p124) bubble alpha0=0.001 mu=0.05 tpoinc=25.1327412287 tskip=6.28318530718
XB125 (p125) bubble alpha0=0.001 mu=0.05 tpoinc=25.1327412287 tskip=6.28318530718
XB126 (p126) bubble alpha0=0.001 mu=0.05 tpoinc=25.1327412287 tskip=6.28318530718
XB127 (p127) bubble alpha0=0.001 mu=0.05 tpoinc=25.1327412287 tskip=6.28318530718
XB128 (p128) bubble alpha0=0.001 mu=0.05 tpoinc=25.1327412287 tskip=6.28318530718
XB129 (p129) bubble alpha0=0.001 mu=0.05 tpoinc=25.1327412287 tskip=6.28318530718
XB130 (p130) bubble alpha0=0.001 mu=0.05 tpoinc=25.1327412287 tskip=6.28318530718
XB131 (p131) bubble alpha0=0.001 mu=0.05 tpoinc=25.1327412287 tskip=6.28318530718
XB132 (p132) bubble alpha0=0.001 mu=0.05 tpoinc=25.1327412287 tskip=6.28318530718
XB133 (p133) bubble alpha0=0.001 mu=0.05 tpoinc=25.1327412287 tskip=6.28318530718
XB134 (p134) bubble alpha0=0.001 mu=0.05 tpoinc=25.1327412287 tskip=6.28318530718
XB135 (p135) bubble alpha0=0.001 mu=0.05 tpoinc=25.1327412287 tskip=6.28318530718
XB136 (p136) bubble alpha0=0.001 mu=0.05 tpoinc=25.1327412287 tskip=6.28318530718
XB137 (p137) bubble alpha0=0.001 mu=0.05 tpoinc=25.1327412287 tskip=6.28318530718
XB138 (p138) bubble alpha0=0.001 mu=0.05 tpoinc=25.1327412287 tskip=6.28318530718
XB139 (p139) bubble alpha0=0.001 mu=0.05 tpoinc=25.1327412287 tskip=6.28318530718
XB140 (p140) bubble alpha0=0.001 mu=0.05 tpoinc=25.1327412287 tskip=6.28318530718
XB141 (p141) bubble alpha0=0.001 mu=0.05 tpoinc=25.1327412287 tskip=6.28318530718
XB142 (p142) bubble alpha0=0.001 mu=0.05 tpoinc=25.1327412287 tskip=6.28318530718
XB143 (p143) bubble alpha0=0.001 mu=0.05 tpoinc=25.1327412287 tskip=6.28318530718
XB144 (p144) bubble alpha0=0.001 mu=0.05 tpoinc=25.1327412287 tskip=6.28318530718
XB145 (p145) bubble alpha0=0.001 mu=0.05 tpoinc=25.1327412287 tskip=6.28318530718
XB146 (p146) bubble alpha0=0.001 mu=0.05 tpoinc=25.1327412287 tskip=6.28318530718
XB147 (p147) bubble alpha0=0.001 mu=0.05 tpoinc=25.1327412287 tskip=6.28318530718
XB148 (p148) bubble alpha0=0.001 mu=0.05 tpoinc=25.1327412287 tskip=6.28318530718
XB149 (p149) bubble alpha0=0.001 mu=0.05 tpoinc=25.1327412287 tskip=6.28318530718
XB150 (p150) bubble alpha0=0.001 mu=0.05 tpoinc=25.1327412287 tskip=6.28318530718
XB151 (p151) bubble alpha0=0.001 mu=0.05 tpoinc=25.1327412287 tskip=6.28318530718
XB152 (p152) bubble alpha0=0.001 mu=0.05 tpoinc=25.1327412287 tskip=6.28318530718
XB153 (p153) bubble alpha0=0.001 mu=0.05 tpoinc=25.1327412287 tskip=6.28318530718
XB154 (p154) bubble alpha0=0.001 mu=0.05 tpoinc=25.1327412287 tskip=6.28318530718
XB155 (p155) bubble alpha0=0.001 mu=0.05 tpoinc=25.1327412287 tskip=6.28318530718
XB156 (p156) bubble alpha0=0.001 mu=0.05 tpoinc=25.1327412287 tskip=6.28318530718
XB157 (p157) bubble alpha0=0.001 mu=0.05 tpoinc=25.1327412287 tskip=6.28318530718
XB158 (p158) bubble alpha0=0.001 mu=0.05 tpoinc=25.1327412287 tskip=6.28318530718
XB159 (p159) bubble alpha0=0.001 mu=0.05 tpoinc=25.1327412287 tskip=6.28318530718
XB160 (p160) bubble alpha0=0.001 mu=0.05 tpoinc=25.1327412287 tskip=6.28318530718
XB161 (p161) bubble alpha0=0.001 mu=0.05 tpoinc=25.1327412287 tskip=6.28318530718
XB162 (p162) bubble alpha0=0.001 mu=0.05 tpoinc=25.1327412287 tskip=6.28318530718
XB163 (p163) bubble alpha0=0.001 mu=0.05 tpoinc=25.1327412287 tskip=6.28318530718
XB164 (p164) bubble alpha0=0.001 mu=0.05 tpoinc=25.1327412287 tskip=6.28318530718
XB165 (p165) bubble alpha0=0.001 mu=0.05 tpoinc=25.1327412287 tskip=6.28318530718
XB166 (p166) bubble alpha0=0.001 mu=0.05 tpoinc=25.1327412287 tskip=6.28318530718
XB167 (p167) bubble alpha0=0.001 mu=0.05 tpoinc=25.1327412287 tskip=6.28318530718
XB168 (p168) bubble alpha0=0.001 mu=0.05 tpoinc=25.1327412287 tskip=6.28318530718
XB169 (p169) bubble alpha0=0.001 mu=0.05 tpoinc=25.1327412287 tskip=6.28318530718
XB170 (p170) bubble alpha0=0.001 mu=0.05 tpoinc=25.1327412287 tskip=6.28318530718
XB171 (p171) bubble alpha0=0.001 mu=0.05 tpoinc=25.1327412287 tskip=6.28318530718
XB172 (p172) bubble alpha0=0.001 mu=0.05 tpoinc=25.1327412287 tskip=6.28318530718
XB173 (p173) bubble alpha0=0.001 mu=0.05 tpoinc=25.1327412287 tskip=6.28318530718
XB174 (p174) bubble alpha0=0.001 mu=0.05 tpoinc=25.1327412287 tskip=6.28318530718
XB175 (p175) bubble alpha0=0.001 mu=0.05 tpoinc=25.1327412287 tskip=6.28318530718
XB176 (p176) bubble alpha0=0.001 mu=0.05 tpoinc=25.1327412287 tskip=6.28318530718
XB177 (p177) bubble alpha0=0.001 mu=0.05 tpoinc=25.1327412287 tskip=6.28318530718
XB178 (p178) bubble alpha0=0.001 mu=0.05 tpoinc=25.1327412287 tskip=6.28318530718
XB179 (p179) bubble alpha0=0.001 mu=0.05 tpoinc=25.1327412287 tskip=6.28318530718
XB180 (p180) bubble alpha0=0.001 mu=0.05 tpoinc=25.1327412287 tskip=6.28318530718
XB181 (p181) bubble alpha0=0.001 mu=0.05 tpoinc=25.1327412287 tskip=6.28318530718
XB182 (p182) bubble alpha0=0.001 mu=0.05 tpoinc=25.1327412287 tskip=6.28318530718
XB183 (p183) bubble alpha0=0.001 mu=0.05 tpoinc=25.1327412287 tskip=6.28318530718
XB184 (p184) bubble alpha0=0.001 mu=0.05 tpoinc=25.1327412287 tskip=6.28318530718
XB185 (p185) bubble alpha0=0.001 mu=0.05 tpoinc=25.1327412287 tskip=6.28318530718
XB186 (p186) bubble alpha0=0.001 mu=0.05 tpoinc=25.1327412287 tskip=6.28318530718
XB187 (p187) bubble alpha0=0.001 mu=0.05 tpoinc=25.1327412287 tskip=6.28318530718
XB188 (p188) bubble alpha0=0.001 mu=0.05 tpoinc=25.1327412287 tskip=6.28318530718
XB189 (p189) bubble alpha0=0.001 mu=0.05 tpoinc=25.1327412287 tskip=6.28318530718
XB190 (p190) bubble alpha0=0.001 mu=0.05 tpoinc=25.1327412287 tskip=6.28318530718
XB191 (p191) bubble alpha0=0.001 mu=0.05 tpoinc=25.1327412287 tskip=6.28318530718
XB192 (p192) bubble alpha0=0.001 mu=0.05 tpoinc=25.1327412287 tskip=6.28318530718
XB193 (p193) bubble alpha0=0.001 mu=0.05 tpoinc=25.1327412287 tskip=6.28318530718
XB194 (p194) bubble alpha0=0.001 mu=0.05 tpoinc=25.1327412287 tskip=6.28318530718
XB195 (p195) bubble alpha0=0.001 mu=0.05 tpoinc=25.1327412287 tskip=6.28318530718
XB196 (p196) bubble alpha0=0.001 mu=0.05 tpoinc=25.1327412287 tskip=6.28318530718
XB197 (p197) bubble alpha0=0.001 mu=0.05 tpoinc=25.1327412287 tskip=6.28318530718
XB198 (p198) bubble alpha0=0.001 mu=0.05 tpoinc=25.1327412287 tskip=6.28318530718
XB199 (p199) bubble alpha0=0.001 mu=0.05 tpoinc=25.1327412287 tskip=6.28318530718
XL0 (pb p1) bubble_link
XL1 (p1 p2) bubble_link
XL2 (p2 p3) bubble_link
XL3 (p3 p4) bubble_link
XL4 (p4 p5) bubble_link
XL5 (p5 p6) bubble_link
XL6 (p6 p7) bubble_link
XL7 (p7 p8) bubble_link
XL8 (p8 p9) bubble_link
XL9 (p9 p10) bubble_link
XL10 (p10 p11) bubble_link
XL11 (p11 p12) bubble_link
XL12 (p12 p13) bubble_link
XL13 (p13 p14) bubble_link
XL14 (p14 p15) bubble_link
XL15 (p15 p16) bubble_link
XL16 (p16 p17) bubble_link
XL17 (p17 p18) bubble_link
XL18 (p18 p19) bubble_link
XL19 (p19 p20) bubble_link
XL20 (p20 p21) bubble_link
XL21 (p21 p22) bubble_link
XL22 (p22 p23) bubble_link
XL23 (p23 p24) bubble_link
XL24 (p24 p25) bubble_link
XL25 (p25 p26) bubble_link
XL26 (p26 p27) bubble_link
XL27 (p27 p28) bubble_link
XL28 (p28 p29) bubble_link
XL29 (p29 p30) bubble_link
XL30 (p30 p31) bubble_link
XL31 (p31 p32) bubble_link
XL32 (p32 p33) bubble_link
XL33 (p33 p34) bubble_link
XL34 (p34 p35) bubble_link
XL35 (p35 p36) bubble_link
XL36 (p36 p37) bubble_link
XL37 (p37 p38) bubble_link
XL38 (p38 p39) bubble_link
XL39 (p39 p40) bubble_link
XL40 (p40 p41) bubble_link
XL41 (p41 p42) bubble_link
XL42 (p42 p43) bubble_link
XL43 (p43 p44) bubble_link
XL44 (p44 p45) bubble_link
XL45 (p45 p46) bubble_link
XL46 (p46 p47) bubble_link
XL47 (p47 p48) bubble_link
XL48 (p48 p49) bubble_link
XL49 (p49 p50) bubble_link
XL50 (p50 p51) bubble_link
XL51 (p51 p52) bubble_link
XL52 (p52 p53) bubble_link
XL53 (p53 p54) bubble_link
XL54 (p54 p55) bubble_link
XL55 (p55 p56) bubble_link
XL56 (p56 p57) bubble_link
XL57 (p57 p58) bubble_link
XL58 (p58 p59) bubble_link
XL59 (p59 p60) bubble_link
XL60 (p60 p61) bubble_link
XL61 (p61 p62) bubble_link
XL62 (p62 p63) bubble_link
XL63 (p63 p64) bubble_link
XL64 (p64 p65) bubble_link
XL65 (p65 p66) bubble_link
XL66 (p66 p67) bubble_link
XL67 (p67 p68) bubble_link
XL68 (p68 p69) bubble_link
XL69 (p69 p70) bubble_link
XL70 (p70 p71) bubble_link
XL71 (p71 p72) bubble_link
XL72 (p72 p73) bubble_link
XL73 (p73 p74) bubble_link
XL74 (p74 p75) bubble_link
XL75 (p75 p76) bubble_link
XL76 (p76 p77) bubble_link
XL77 (p77 p78) bubble_link
XL78 (p78 p79) bubble_link
XL79 (p79 p80) bubble_link
XL80 (p80 p81) bubble_link
XL81 (p81 p82) bubble_link
XL82 (p82 p83) bubble_link
XL83 (p83 p84) bubble_link
XL84 (p84 p85) bubble_link
XL85 (p85 p86) bubble_link
XL86 (p86 p87) bubble_link
XL87 (p87 p88) bubble_link
XL88 (p88 p89) bubble_link
XL89 (p89 p90) bubble_link
XL90 (p90 p91) bubble_link
XL91 (p91 p92) bubble_link
XL92 (p92 p93) bubble_link
XL93 (p93 p94) bubble_link
XL94 (p94 p95) bubble_link
XL95 (p95 p96) bubble_link
XL96 (p96 p97) bubble_link
XL97 (p97 p98) bubble_link
XL98 (p98 p99) bubble_link
XL99 (p99 p100) bubble_link
XL100 (p100 p101) bubble_link
XL101 (p101 p102) bubble_link
XL102 (p102 p103) bubble_link
XL103 (p103 p104) bubble_link
XL104 (p104 p105) bubble_link
XL105 (p105 p106) bubble_link
XL106 (p106 p107) bubble_link
XL107 (p107 p108) bubble_link
XL108 (p108 p109) bubble_link
XL109 (p109 p110) bubble_link
XL110 (p110 p111) bubble_link
XL111 (p111 p112) bubble_link
XL112 (p112 p113) bubble_link
XL113 (p113 p114) bubble_link
XL114 (p114 p115) bubble_link
XL115 (p115 p116) bubble_link
XL116 (p116 p117) bubble_link
XL117 (p117 p118) bubble_link
XL118 (p118 p119) bubble_link
XL119 (p119 p120) bubble_link
XL120 (p120 p121) bubble_link
XL121 (p121 p122) bubble_link
XL122 (p122 p123) bubble_link
XL123 (p123 p124) bubble_link
XL124 (p124 p125) bubble_link
XL125 (p125 p126) bubble_link
XL126 (p126 p127) bubble_link
XL127 (p127 p128) bubble_link
XL128 (p128 p129) bubble_link
XL129 (p129 p130) bubble_link
XL130 (p130 p131) bubble_link
XL131 (p131 p132) bubble_link
XL132 (p132 p133) bubble_link
XL133 (p133 p134) bubble_link
XL134 (p134 p135) bubble_link
XL135 (p135 p136) bubble_link
XL136 (p136 p137) bubble_link
XL137 (p137 p138) bubble_link
XL138 (p138 p139) bubble_link
XL139 (p139 p140) bubble_link
XL140 (p140 p141) bubble_link
XL141 (p141 p142) bubble_link
XL142 (p142 p143) bubble_link
XL143 (p143 p144) bubble_link
XL144 (p144 p145) bubble_link
XL145 (p145 p146) bubble_link
XL146 (p146 p147) bubble_link
XL147 (p147 p148) bubble_link
XL148 (p148 p149) bubble_link
XL149 (p149 p150) bubble_link
XL150 (p150 p151) bubble_link
XL151 (p151 p152) bubble_link
XL152 (p152 p153) bubble_link
XL153 (p153 p154) bubble_link
XL154 (p154 p155) bubble_link
XL155 (p155 p156) bubble_link
XL156 (p156 p157) bubble_link
XL157 (p157 p158) bubble_link
XL158 (p158 p159) bubble_link
XL159 (p159 p160) bubble_link
XL160 (p160 p161) bubble_link
XL161 (p161 p162) bubble_link
XL162 (p162 p163) bubble_link
XL163 (p163 p164) bubble_link
XL164 (p164 p165) bubble_link
XL165 (p165 p166) bubble_link
XL166 (p166 p167) bubble_link
XL167 (p167 p168) bubble_link
XL168 (p168 p169) bubble_link
XL169 (p169 p170) bubble_link
XL170 (p170 p171) bubble_link
XL171 (p171 p172) bubble_link
XL172 (p172 p173) bubble_link
XL173 (p173 p174) bubble_link
XL174 (p174 p175) bubble_link
XL175 (p175 p176) bubble_link
XL176 (p176 p177) bubble_link
XL177 (p177 p178) bubble_link
XL178 (p178 p179) bubble_link
XL179 (p179 p180) bubble_link
XL180 (p180 p181) bubble_link
XL181 (p181 p182) bubble_link
XL182 (p182 p183) bubble_link
XL183 (p183 p184) bubble_link
XL184 (p184 p185) bubble_link
XL185 (p185 p186) bubble_link
XL186 (p186 p187) bubble_link
XL187 (p187 p188) bubble_link
XL188 (p188 p189) bubble_link
XL189 (p189 p190) bubble_link
XL190 (p190 p191) bubble_link
XL191 (p191 p192) bubble_link
XL192 (p192 p193) bubble_link
XL193 (p193 p194) bubble_link
XL194 (p194 p195) bubble_link
XL195 (p195 p196) bubble_link
XL196 (p196 p197) bubble_link
XL197 (p197 p198) bubble_link
XL198 (p198 p199) bubble_link
XL199 (p199 pb) bubble_link

save pb
tr tran stop=753.982236862 step=0.502655
