// benchmark__psp103_inverter_card_tran -- Spectre translation of circuits/benchmark/psp103_inverter_card_tran.net (scripts/spectre_golden/net2spectre.py)
simulator lang=spectre
global 0
opts options reltol=1e-6 vabstol=1e-9 iabstol=1e-15 temp=27 tnom=27 gmin=1e-18 save=selected

ahdl_include "benchmark/models/psp103/psp103.va"

Vdd (vdd 0) vsource dc=1.2
Vmeas (vss 0) vsource dc=0
V1 (in 0) vsource dc=0 type=pulse val0=0 val1=1.2 delay=0 rise=2e-10 fall=1e-10 width=1e-09 period=2e-09
model XMP_model PSP103VA A1L=0 A1O=1 A1W=0 A2O=10 A3L=0 A3O=1 A3W=0 A4L=0 A4O=0 A4W=0 AGIDLDW=0 AGIDLW=50 ALP1L1=0.025 ALP1L2=0.1 ALP1LEXP=0.4 ALP1W=0.0085 ALP2L1=0.5 ALP2L2=0.5 ALP2LEXP=0 ALP2W=-0.2 ALPL=0.007 ALPLEXP=0.6 ALPW=0.05 AXL=0.2 AXO=20 BETW1=0.05 BETW2=-0.02 BGIDLDO=41 BGIDLO=35 CBBTBOT=1e-12 CBBTBOTD=1e-12 CBBTGAT=1e-18 CBBTGATD=1e-18 CBBTSTI=1e-18 CBBTSTID=1e-18 CFBO=0.3 CFL=0.0003 CFLEXP=2 CFRDW=0 CFRW=5e-17 CFW=0.005 CGBOVL=0 CGIDLDO=0 CGIDLO=0.15 CHIBO=3.1 CJORBOT=0.001 CJORBOTD=0.001 CJORGAT=5e-10 CJORGATD=1e-09 CJORSTI=1e-09 CJORSTID=1e-09 CSL=0 CSLEXP=1 CSLW=0 CSO=0.01 CSRHBOT=500 CSRHBOTD=100 CSRHGAT=1000 CSRHGATD=0.0001 CSRHSTI=0 CSRHSTID=0.0001 CSW=0 CTATBOT=500 CTATBOTD=100 CTATGAT=1000 CTATGATD=0.0001 CTATSTI=0 CTATSTID=0.0001 CTL=0.04 CTLEXP=0.6 CTLW=0 CTO=5e-15 CTW=0 DELVTACL=0 DELVTACLEXP=1 DELVTACLW=0 DELVTACO=0 DELVTACW=0 DLQ=0 DLSIL=0 DNSUBO=0 DPHIBL=0 DPHIBLEXP=1 DPHIBLW=0 DPHIBO=0 DPHIBW=0 DVSBNUDO=1 DWQ=0 EPSROXO=3.9 FACNEFFACL=0 FACNEFFACLW=0 FACNEFFACO=0.8 FACNEFFACW=0 FBBTRBOT=1000000000 FBBTRBOTD=1000000000 FBBTRGAT=1000000000 FBBTRGATD=1000000000 FBBTRSTI=1000000000 FBBTRSTID=1000000000 FBET1=-0.3 FBET1W=0.15 FBET2=50 FETAO=1 FJUNQ=0.03 FJUNQD=0.03 FNTO=1 FOL1=0.02 FOL2=5e-06 GC2O=1 GC3O=-1 GCOO=5 GFACNUDL=0 GFACNUDLEXP=1 GFACNUDLW=0 GFACNUDO=0.1 GFACNUDW=0 IDSATRBOT=5e-09 IDSATRBOTD=1e-12 IDSATRGAT=1e-18 IDSATRGATD=1e-18 IDSATRSTI=1e-18 IDSATRSTID=1e-18 IGINVLW=50 IGOVDW=0 IGOVW=10 IMAX=1000 LAP=1e-08 LOV=1e-08 LOVD=0 LP1=1.5e-07 LP1W=-0.025 LP2=8.5e-10 LPCK=5.5e-08 LPCKW=0 LVARL=0 LVARO=-1e-08 LVARW=0 MEFFTATBOT=0.25 MEFFTATBOTD=0.25 MEFFTATGAT=0.25 MEFFTATGATD=0.25 MEFFTATSTI=0.25 MEFFTATSTID=0.25 MUEO=0.6 MUEW=-0.012 NFALW=8e+22 NFBLW=30000000 NFCLW=0 NOVDO=5e+25 NOVO=7.5e+25 NPCK=1e+24 NPCKW=0 NPL=1e-17 NPO=1.5e+26 NSLPO=0.05 NSUBO=3e+23 NSUBW=0 PBOT=0.35 PBOTD=0.5 PBRBOT=3 PBRBOTD=4 PBRGAT=3 PBRGATD=4 PBRSTI=4 PBRSTID=4 PGAT=0.6 PGATD=0.5 PHIGBOT=1.16 PHIGBOTD=1.16 PHIGGAT=1.16 PHIGGATD=1.16 PHIGSTI=1.16 PHIGSTID=1.16 PSTI=0.35 PSTID=0.5 QMC=1 RBULKO=0 RGO=0 RINT=0 RJUNDO=0 RJUNSO=0 RSBO=0 RSGO=0 RSHG=0 RSW1=50 RSW2=0.05 RVPOLY=0 RWELLO=0 STA2O=-0.5 STBETL=-0.02 STBETLW=-0.003 STBETO=1.75 STBETW=-0.002 STBGIDLDO=0 STBGIDLO=-0.0005 STCSO=-5 STFBBTBOT=-0.001 STFBBTBOTD=-0.001 STFBBTGAT=-0.01 STFBBTGATD=-0.001 STFBBTSTI=-0.001 STFBBTSTID=-0.001 STIGO=1.5 STMUEO=0.5 STRSO=-2 STTHEMUO=-0.1 STTHESATL=-0.025 STTHESATLW=-0.005 STTHESATO=1.5 STTHESATW=-0.02 STVFBL=0 STVFBLW=0 STVFBO=0.0005 STVFBW=0 STXCORO=1.25 SWGEO=1 SWJUNEXP=0 THEMUO=2.75 THESATBO=0.15 THESATGO=0.75 THESATL=0.6 THESATLEXP=0.75 THESATLW=0 THESATO=1e-06 THESATW=-0.01 TOXO=1.5e-09 TOXOVDO=2e-09 TOXOVO=1.5e-09 TR=27 TRJ=27 TYPE=-1 UO=0.035 VBIRBOT=0.75 VBIRBOTD=1 VBIRGAT=0.75 VBIRGATD=1 VBIRSTI=1 VBIRSTID=1 VBRBOT=10 VBRBOTD=10 VBRGAT=10 VBRGATD=10 VBRSTI=10 VBRSTID=10 VFBL=0 VFBLW=0 VFBO=-1.1 VFBW=0 VJUNREF=2.5 VJUNREFD=2.5 VNSUBO=0 VPO=0.25 VSBNUDO=0 WBET=5e-10 WOT=0 WSEG=1.5e-10 WSEGP=9e-09 WVARL=0 WVARO=1e-08 WVARW=0 XCORL=0.002 XCORLW=-0.0035 XCORO=0.15 XCORW=-0.03 XJUNGAT=1e-09 XJUNGATD=1e-07 XJUNSTI=1e-08 XJUNSTID=1e-07
XMP (out in vdd vdd) XMP_model ABDRAIN=1e-12 ABSOURCE=1e-12 DTA=0 L=1e-07 LGDRAIN=1e-06 LGSOURCE=1e-06 LSDRAIN=1e-06 LSSOURCE=1e-06 MULT=1 SA=0 SB=0 W=1e-06
model XMN_model PSP103VA A1L=0 A1O=1 A1W=0 A2O=10 A3L=0 A3O=1 A3W=0 A4L=0 A4O=0 A4W=0 AGIDLDW=0 AGIDLW=50 ALP1L1=0.025 ALP1L2=0.1 ALP1LEXP=0.4 ALP1W=0.0085 ALP2L1=0.5 ALP2L2=0.5 ALP2LEXP=0 ALP2W=-0.2 ALPL=0.007 ALPLEXP=0.6 ALPW=0.05 AXL=0.2 AXO=20 BETW1=0.05 BETW2=-0.02 BGIDLDO=41 BGIDLO=35 CBBTBOT=1e-12 CBBTBOTD=1e-12 CBBTGAT=1e-18 CBBTGATD=1e-18 CBBTSTI=1e-18 CBBTSTID=1e-18 CFBO=0.3 CFL=0.0003 CFLEXP=2 CFRDW=0 CFRW=5e-17 CFW=0.005 CGBOVL=0 CGIDLDO=0 CGIDLO=0.15 CHIBO=3.1 CJORBOT=0.001 CJORBOTD=0.001 CJORGAT=5e-10 CJORGATD=1e-09 CJORSTI=1e-09 CJORSTID=1e-09 CSL=0 CSLEXP=1 CSLW=0 CSO=0.01 CSRHBOT=500 CSRHBOTD=100 CSRHGAT=1000 CSRHGATD=0.0001 CSRHSTI=0 CSRHSTID=0.0001 CSW=0 CTATBOT=500 CTATBOTD=100 CTATGAT=1000 CTATGATD=0.0001 CTATSTI=0 CTATSTID=0.0001 CTL=0.04 CTLEXP=0.6 CTLW=0 CTO=5e-15 CTW=0 DELVTACL=0 DELVTACLEXP=1 DELVTACLW=0 DELVTACO=0 DELVTACW=0 DLQ=0 DLSIL=0 DNSUBO=0 DPHIBL=0 DPHIBLEXP=1 DPHIBLW=0 DPHIBO=0 DPHIBW=0 DVSBNUDO=1 DWQ=0 EPSROXO=3.9 FACNEFFACL=0 FACNEFFACLW=0 FACNEFFACO=0.8 FACNEFFACW=0 FBBTRBOT=1000000000 FBBTRBOTD=1000000000 FBBTRGAT=1000000000 FBBTRGATD=1000000000 FBBTRSTI=1000000000 FBBTRSTID=1000000000 FBET1=-0.3 FBET1W=0.15 FBET2=50 FETAO=1 FJUNQ=0.03 FJUNQD=0.03 FNTO=1 FOL1=0.02 FOL2=5e-06 GC2O=1 GC3O=-1 GCOO=5 GFACNUDL=0 GFACNUDLEXP=1 GFACNUDLW=0 GFACNUDO=0.1 GFACNUDW=0 IDSATRBOT=5e-09 IDSATRBOTD=1e-12 IDSATRGAT=1e-18 IDSATRGATD=1e-18 IDSATRSTI=1e-18 IDSATRSTID=1e-18 IGINVLW=50 IGOVDW=0 IGOVW=10 IMAX=1000 LAP=1e-08 LOV=1e-08 LOVD=0 LP1=1.5e-07 LP1W=-0.025 LP2=8.5e-10 LPCK=5.5e-08 LPCKW=0 LVARL=0 LVARO=-1e-08 LVARW=0 MEFFTATBOT=0.25 MEFFTATBOTD=0.25 MEFFTATGAT=0.25 MEFFTATGATD=0.25 MEFFTATSTI=0.25 MEFFTATSTID=0.25 MUEO=0.6 MUEW=-0.012 NFALW=8e+22 NFBLW=30000000 NFCLW=0 NOVDO=5e+25 NOVO=7.5e+25 NPCK=1e+24 NPCKW=0 NPL=1e-17 NPO=1.5e+26 NSLPO=0.05 NSUBO=3e+23 NSUBW=0 PBOT=0.35 PBOTD=0.5 PBRBOT=3 PBRBOTD=4 PBRGAT=3 PBRGATD=4 PBRSTI=4 PBRSTID=4 PGAT=0.6 PGATD=0.5 PHIGBOT=1.16 PHIGBOTD=1.16 PHIGGAT=1.16 PHIGGATD=1.16 PHIGSTI=1.16 PHIGSTID=1.16 PSTI=0.35 PSTID=0.5 QMC=1 RBULKO=0 RGO=0 RINT=0 RJUNDO=0 RJUNSO=0 RSBO=0 RSGO=0 RSHG=0 RSW1=50 RSW2=0.05 RVPOLY=0 RWELLO=0 STA2O=-0.5 STBETL=-0.02 STBETLW=-0.003 STBETO=1.75 STBETW=-0.002 STBGIDLDO=0 STBGIDLO=-0.0005 STCSO=-5 STFBBTBOT=-0.001 STFBBTBOTD=-0.001 STFBBTGAT=-0.01 STFBBTGATD=-0.001 STFBBTSTI=-0.001 STFBBTSTID=-0.001 STIGO=1.5 STMUEO=0.5 STRSO=-2 STTHEMUO=-0.1 STTHESATL=-0.025 STTHESATLW=-0.005 STTHESATO=1.5 STTHESATW=-0.02 STVFBL=0 STVFBLW=0 STVFBO=0.0005 STVFBW=0 STXCORO=1.25 SWGEO=1 SWJUNEXP=0 THEMUO=2.75 THESATBO=0.15 THESATGO=0.75 THESATL=0.6 THESATLEXP=0.75 THESATLW=0 THESATO=1e-06 THESATW=-0.01 TOXO=1.5e-09 TOXOVDO=2e-09 TOXOVO=1.5e-09 TR=27 TRJ=27 TYPE=1 UO=0.035 VBIRBOT=0.75 VBIRBOTD=1 VBIRGAT=0.75 VBIRGATD=1 VBIRSTI=1 VBIRSTID=1 VBRBOT=10 VBRBOTD=10 VBRGAT=10 VBRGATD=10 VBRSTI=10 VBRSTID=10 VFBL=0 VFBLW=0 VFBO=-1.1 VFBW=0 VJUNREF=2.5 VJUNREFD=2.5 VNSUBO=0 VPO=0.25 VSBNUDO=0 WBET=5e-10 WOT=0 WSEG=1.5e-10 WSEGP=9e-09 WVARL=0 WVARO=1e-08 WVARW=0 XCORL=0.002 XCORLW=-0.0035 XCORO=0.15 XCORW=-0.03 XJUNGAT=1e-09 XJUNGATD=1e-07 XJUNSTI=1e-08 XJUNSTID=1e-07
XMN (out in vss vss) XMN_model ABDRAIN=1e-12 ABSOURCE=1e-12 DTA=0 L=1e-07 LGDRAIN=1e-06 LGSOURCE=1e-06 LSDRAIN=1e-06 LSSOURCE=1e-06 MULT=1 SA=0 SB=0 W=1e-06
C3 (in vss) capacitor c=3.84e-16
C2 (out vss) capacitor c=5.76e-16

save in out
tr tran stop=1e-08 step=1e-11
