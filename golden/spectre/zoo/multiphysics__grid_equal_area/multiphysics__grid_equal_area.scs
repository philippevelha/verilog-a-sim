// multiphysics__grid_equal_area -- Spectre translation of circuits/multiphysics/grid_equal_area.net (scripts/spectre_golden/net2spectre.py)
simulator lang=spectre
global 0
opts options reltol=1e-6 vabstol=1e-9 iabstol=1e-15 temp=27 tnom=27 gmin=1e-18 save=selected

ahdl_include "models/multiphysics/powergrid/grid_parts.va"

XINF (inf) slack
XG1 (g1) machine pm=0.8 h=5
XL1 (g1 inf) line bmax=1.6 t_open=1 t_close=1.255
XG2 (g2) machine pm=0.8 h=5
XL2 (g2 inf) line bmax=1.6 t_open=1 t_close=1.27

save g1 g2
tr tran stop=3 step=0.001
