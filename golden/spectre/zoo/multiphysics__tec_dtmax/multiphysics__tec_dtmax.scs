// multiphysics__tec_dtmax -- Spectre translation of circuits/multiphysics/tec_dtmax.net (scripts/spectre_golden/net2spectre.py)
simulator lang=spectre
global 0
opts options reltol=1e-6 vabstol=1e-9 iabstol=1e-15 temp=27 tnom=27 gmin=1e-18 save=selected

ahdl_include "models/multiphysics/tec/tec.va"
ahdl_include "models/multiphysics/tec/thermal_parts.va"

V1 (drv 0) vsource dc=0
X1 (drv 0 cold hot) tec alpha1=0 tcr=0
XA (hot) ambient tamb=300

save cold V1:p
sw dc dev=V1 param=dc start=0 stop=20 step=0.25
