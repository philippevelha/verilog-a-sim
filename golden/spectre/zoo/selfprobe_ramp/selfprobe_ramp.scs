// selfprobe_ramp -- Spectre translation of circuits/selfprobe_ramp.net (scripts/spectre_golden/net2spectre.py)
simulator lang=spectre
global 0
opts options reltol=1e-6 vabstol=1e-9 iabstol=1e-15 temp=27 tnom=27 gmin=1e-18 save=selected

ahdl_include "models/selfprobe_rc.va"

V1 (s 0) vsource dc=0 type=sine sinedc=0 ampl=1 freq=1000000
Rs (s a) resistor r=50
M1 (a 0 out) selfprobe_rc

opts2 options save=lvlpub nestlvl=1
tr tran stop=2e-06 step=2e-09
