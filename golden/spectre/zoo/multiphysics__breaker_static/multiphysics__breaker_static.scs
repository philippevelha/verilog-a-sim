// multiphysics__breaker_static -- Spectre translation of circuits/multiphysics/breaker_static.net (scripts/spectre_golden/net2spectre.py)
simulator lang=spectre
global 0
opts options reltol=1e-6 vabstol=1e-9 iabstol=1e-15 temp=27 tnom=27 gmin=1e-18 save=selected

ahdl_include "models/multiphysics/breaker/breaker.va"

VT (trav 0) vsource dc=-0.001 type=pwl wave=[ \
    0 -0.001 0.01 -0.001 0.0142 0.02 ]
VC (ctl 0) vsource dc=10 type=pwl wave=[ \
    0 10 0.02 10 1 1000 ]
G1 (0 p ctl 0) vccs gm=1
X1 (p 0 trav) breaker k_blast=0

save p ctl
tr tran stop=1 step=0.0001
