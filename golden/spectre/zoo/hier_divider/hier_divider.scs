// hier_divider -- Spectre translation of circuits/hier_divider.net (scripts/spectre_golden/net2spectre.py)
simulator lang=spectre
global 0
opts options reltol=1e-6 vabstol=1e-9 iabstol=1e-15 temp=27 tnom=27 gmin=1e-18 save=selected

ahdl_include "models/series_divider.va"
ahdl_include "models/leg.va"

V1 (in 0) vsource dc=1
D1 (in mid) series_divider
R1 (mid 0) resistor r=1000

opts2 options save=lvlpub nestlvl=1
op1 dc
