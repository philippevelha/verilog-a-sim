// benchmark__cap_fast_edge -- Spectre translation of circuits/benchmark/cap_fast_edge.net (scripts/spectre_golden/net2spectre.py)
simulator lang=spectre
global 0
opts options reltol=1e-6 vabstol=1e-9 iabstol=1e-15 temp=27 tnom=27 gmin=1e-18 save=selected

V1 (in 0) vsource dc=0 type=pulse val0=0 val1=1.2 delay=0 rise=2e-10 fall=1e-10 width=1e-09 period=2e-09
C1 (in 0) capacitor c=1.7e-15
R1 (in out) resistor r=10000
R2 (out 0) resistor r=10000

opts2 options save=lvlpub nestlvl=1
tr tran stop=1e-09 step=1e-11
