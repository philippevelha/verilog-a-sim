// snn__transistor__fig5_tx -- Spectre translation of circuits/snn/transistor/fig5_tx.net (scripts/spectre_golden/net2spectre.py)
simulator lang=spectre
global 0
opts options reltol=1e-6 vabstol=1e-9 iabstol=1e-15 temp=27 tnom=27 gmin=1e-18 save=selected

ahdl_include "models/sg13g2/psp103/psp103.va"
ahdl_include "models/snn/vswitch.va"
ahdl_include "models/snn/rram.va"

model hvn_w10000n_l450n_ng1 PSP103VA TYPE=1 TR=27 DTA=0 SWGEO=1 SWIGATE=1 SWIMPACT=1 SWGIDL=0 SWJUNCAP=3 SWJUNASYM=0 SWNUD=0 SWEDGE=0 SWDELVTAC=0 SWIGN=1 QMC=1 LVARO=3.499e-08 LVARL=-0.09125 LVARW=0 LAP=6.3866e-08 WVARO=0 WVARL=0 WVARW=0 WOT=3e-08 DLQ=5.2202e-08 DWQ=3e-08 VFBO=-0.89839 VFBL=0.15096 VFBW=0.0017033 VFBLW=0.019398 STVFBO=0.0008739 STVFBL=0.00014864 STVFBW=-4.6174e-05 STVFBLW=-2.445e-06 ST2VFBO=0 TOXO=7.4256e-09 EPSROXO=3.9 NSUBO=1.8552e+23 NSUBW=-0.0050198 WSEG=1.098e-10 NPCK=3.178e+23 NPCKW=-2.7604 WSEGP=1e-08 LPCK=1e-08 LPCKW=0 FOL1=0.21033 FOL2=0.0026472 FACNEFFACO=1 FACNEFFACL=0 FACNEFFACW=0 FACNEFFACLW=0 GFACNUDO=1 GFACNUDL=0 GFACNUDLEXP=1 GFACNUDW=0 GFACNUDLW=0 VSBNUDO=0 DVSBNUDO=1 VNSUBO=0 NSLPO=0.05 DNSUBO=0.025686 DPHIBO=-0.0607576464 DPHIBL=-0.00546403785 DPHIBLEXP=2.3956 DPHIBW=0.014614 DPHIBLW=-0.017476272 DELVTACO=0 DELVTACL=0 DELVTACLEXP=1 DELVTACW=0 DELVTACLW=0 NPO=3.897e+26 NPL=-0.1215 TOXOVO=7.4256e-09 TOXOVDO=2e-09 LOV=6.3866e-08 LOVD=0 NOVO=5.5814e+24 NOVDO=5e+25 CTO=-0.061658 CTL=0.025 CTLEXP=1.6063 CTW=-0.044911 CTLW=-0.0077386 CTGO=0 CTBO=0 STCTO=1 CFL=0.0048288 CFLEXP=1.3328 CFW=0.037319 CFBO=0.26069 CFDO=0 PSCEL=0 PSCELEXP=2 PSCEW=0 PSCEBO=0 PSCEDO=0 UO=0.046687 FBET1=-0.35712 FBET1W=-0.14995 LP1=4.5615e-08 LP1W=0.4189 FBET2=-1.0245 LP2=9.42e-09 BETW1=0.6567 BETW2=-0.083639 WBET=1.0063e-10 STBETO=1.6942 STBETL=-0.0065587 STBETW=-0.060053 STBETLW=0.00036994 MUEO=0.91692524 MUEW=-0.018226 STMUEO=0.34067 THEMUO=2.5509 STTHEMUO=0.63756 CSO=2.0494 CSL=-0.97261 CSLEXP=0 CSW=0.044205 CSLW=-1.0021 STCSO=2.5545 THECSO=2 STTHECSO=0 XCORO=0.04872 XCORL=-0.27137 XCORW=-0.1948 XCORLW=0 STXCORO=1.1327 FETAO=1.0706 RSW1=321.598966 RSW2=-0.07 STRSO=-0.058157 RSBO=-0.0025425 RSGO=0.10986 THESATO=0.1 THESATL=0.446499 THESATLEXP=1.0973 THESATW=0.082797 THESATLW=-0.032897685 STTHESATO=0.48396 STTHESATL=0.50226 STTHESATW=0.049985 STTHESATLW=-0.059487 THESATBO=0.06 THESATGO=0.050814 AXO=8.7694 AXL=2.3029 ALPL=0.0019702 ALPLEXP=1.4003 ALPW=1.1052 ALP1L1=0.007475 ALP1LEXP=0.80983 ALP1L2=0.719 ALP1W=0.56703 ALP2L1=5.413e-07 ALP2LEXP=0.2541 ALP2L2=0 ALP2W=-10 VPO=0.06567 A1O=4.7288 A1L=0.052459 A1W=0.024056 A2O=22.013 STA2O=0.018532 A3O=1.2047 A3L=-0.10308 A3W=0.0069117 A4O=0.12894 A4L=-0.05413 A4W=-0.06197 GCOO=0 IGINVLW=0 IGOVW=0 IGOVDW=0 STIGO=2 GC2O=0.375 GC3O=0.063 CHIBO=3.1 AGIDLW=70 AGIDLDW=0 BGIDLO=13 BGIDLDO=41 STBGIDLO=-0.001067 STBGIDLDO=0 CGIDLO=0 CGIDLDO=0 CGBOVL=2.522e-16 CFRDW=0 FNTO=1 FNTEXCL=0 NFALW=1.42e+25 NFBLW=574300000 NFCLW=-3.015e-08 EFO=1 LINTNOI=-3.158e-08 ALPNOI=2.708 WEDGE=1e-08 WEDGEW=0 VFBEDGEO=-1 STVFBEDGEO=0.0005 STVFBEDGEL=0 STVFBEDGEW=0 STVFBEDGELW=0 DPHIBEDGEO=0 DPHIBEDGEL=0 DPHIBEDGELEXP=1 DPHIBEDGEW=0 DPHIBEDGELW=0 NSUBEDGEO=5e+23 NSUBEDGEL=0 NSUBEDGELEXP=1 NSUBEDGEW=0 NSUBEDGELW=0 CTEDGEO=0 CTEDGEL=0 CTEDGELEXP=1 FBETEDGE=0 LPEDGE=1e-08 BETEDGEW=0 STBETEDGEO=1 STBETEDGEL=0 STBETEDGEW=0 STBETEDGELW=0 PSCEEDGEL=0 PSCEEDGELEXP=2 PSCEEDGEW=0 PSCEBEDGEO=0 PSCEDEDGEO=0 CFEDGEL=0 CFEDGELEXP=2 CFEDGEW=0 CFDEDGEO=0 CFBEDGEO=0 FNTEDGEO=1 NFAEDGELW=8e+22 NFBEDGELW=30000000 NFCEDGELW=0 EFEDGEO=1 SAREF=1e-06 SBREF=1e-06 WLOD=0 KUO=0 KVSAT=0 TKUO=0 LKUO=0 WKUO=0 PKUO=0 LLODKUO=0 WLODKUO=0 KVTHO=0 LKVTHO=0 WKVTHO=0 PKVTHO=0 LLODVTH=0 WLODVTH=0 STETAO=0 LODETAO=1 SCREF=1e-06 WEB=0 WEC=0 KVTHOWEO=0 KVTHOWEL=0 KVTHOWEW=0 KVTHOWELW=0 KUOWEO=0 KUOWEL=0 KUOWEW=0 KUOWELW=0 TRJ=21 SWJUNEXP=0 IMAX=0.0020128 FREV=1000 CJORBOT=0.00085856 CJORSTI=2.4557e-11 CJORGAT=1.3846e-11 VBIRBOT=0.74373 VBIRSTI=1.597 VBIRGAT=0.6629 PBOT=0.27424 PSTI=0.16571 PGAT=0.1451 CJORBOTD=0.001 CJORSTID=1e-09 CJORGATD=1e-09 VBIRBOTD=1 VBIRSTID=1 VBIRGATD=1 PBOTD=0.5 PSTID=0.5 PGATD=0.5 PHIGBOT=1.1984 PHIGSTI=1.006 PHIGGAT=0.3 IDSATRBOT=5.397e-08 IDSATRSTI=4.0612e-15 IDSATRGAT=0 CSRHBOT=100 CSRHSTI=0.0001 CSRHGAT=0.0001 XJUNSTI=1.61e-08 XJUNGAT=6.134e-07 PHIGBOTD=1.16 PHIGSTID=1.16 PHIGGATD=1.16 IDSATRBOTD=1e-12 IDSATRSTID=1e-18 IDSATRGATD=1e-18 CSRHBOTD=100 CSRHSTID=0.0001 CSRHGATD=0.0001 XJUNSTID=1e-07 XJUNGATD=1e-07 CTATBOT=100 CTATSTI=0.0001 CTATGAT=0.0001 MEFFTATBOT=0.25 MEFFTATSTI=0.25 MEFFTATGAT=0.25 CTATBOTD=100 CTATSTID=0.0001 CTATGATD=0.0001 MEFFTATBOTD=0.25 MEFFTATSTID=0.25 MEFFTATGATD=0.25 CBBTBOT=1e-12 CBBTSTI=1e-21 CBBTGAT=1e-18 FBBTRBOT=1000000000 FBBTRSTI=1000000000 FBBTRGAT=1000000000 STFBBTBOT=-0.001 STFBBTSTI=-0.001 STFBBTGAT=-0.001 CBBTBOTD=1e-12 CBBTSTID=1e-18 CBBTGATD=1e-18 FBBTRBOTD=1000000000 FBBTRSTID=1000000000 FBBTRGATD=1000000000 STFBBTBOTD=-0.001 STFBBTSTID=-0.001 STFBBTGATD=-0.001 VBRBOT=10 VBRSTI=10 VBRGAT=10 PBRBOT=4 PBRSTI=4 PBRGAT=4 VBRBOTD=10 VBRSTID=10 VBRGATD=10 PBRBOTD=4 PBRSTID=4 PBRGATD=4 VJUNREF=2.5 FJUNQ=0.03 VJUNREFD=2.5 FJUNQD=0.03 RINT=3.0856e-12 RVPOLY=0 DLSIL=0 RSH=0 RSHD=0 CFRW=1.2e-16 RSHG=20 RGO=35 RBULKO=200 RWELLO=200 RJUNSO=225 RJUNDO=225 SWSOA=0 VGS_MAX=3 VGD_MAX=3 VGB_MAX=3 VDS_MAX=3 VDB_MAX=1.6 VSB_MAX=1.6
model hvn_w1000n_l450n_ng1 PSP103VA TYPE=1 TR=27 DTA=0 SWGEO=1 SWIGATE=1 SWIMPACT=1 SWGIDL=0 SWJUNCAP=3 SWJUNASYM=0 SWNUD=0 SWEDGE=0 SWDELVTAC=0 SWIGN=1 QMC=1 LVARO=3.499e-08 LVARL=-0.09125 LVARW=0 LAP=6.3866e-08 WVARO=0 WVARL=0 WVARW=0 WOT=3e-08 DLQ=5.2202e-08 DWQ=3e-08 VFBO=-0.89839 VFBL=0.15096 VFBW=0.0017033 VFBLW=0.019398 STVFBO=0.0008739 STVFBL=0.00014864 STVFBW=-4.6174e-05 STVFBLW=-2.445e-06 ST2VFBO=0 TOXO=7.4256e-09 EPSROXO=3.9 NSUBO=1.8552e+23 NSUBW=-0.0050198 WSEG=1.098e-10 NPCK=3.178e+23 NPCKW=-2.7604 WSEGP=1e-08 LPCK=1e-08 LPCKW=0 FOL1=0.21033 FOL2=0.0026472 FACNEFFACO=1 FACNEFFACL=0 FACNEFFACW=0 FACNEFFACLW=0 GFACNUDO=1 GFACNUDL=0 GFACNUDLEXP=1 GFACNUDW=0 GFACNUDLW=0 VSBNUDO=0 DVSBNUDO=1 VNSUBO=0 NSLPO=0.05 DNSUBO=0.025686 DPHIBO=-0.0607576464 DPHIBL=-0.00546403785 DPHIBLEXP=2.3956 DPHIBW=0.014614 DPHIBLW=-0.017476272 DELVTACO=0 DELVTACL=0 DELVTACLEXP=1 DELVTACW=0 DELVTACLW=0 NPO=3.897e+26 NPL=-0.1215 TOXOVO=7.4256e-09 TOXOVDO=2e-09 LOV=6.3866e-08 LOVD=0 NOVO=5.5814e+24 NOVDO=5e+25 CTO=-0.061658 CTL=0.025 CTLEXP=1.6063 CTW=-0.044911 CTLW=-0.0077386 CTGO=0 CTBO=0 STCTO=1 CFL=0.0048288 CFLEXP=1.3328 CFW=0.037319 CFBO=0.26069 CFDO=0 PSCEL=0 PSCELEXP=2 PSCEW=0 PSCEBO=0 PSCEDO=0 UO=0.046687 FBET1=-0.35712 FBET1W=-0.14995 LP1=4.5615e-08 LP1W=0.4189 FBET2=-1.0245 LP2=9.42e-09 BETW1=0.6567 BETW2=-0.083639 WBET=1.0063e-10 STBETO=1.6942 STBETL=-0.0065587 STBETW=-0.060053 STBETLW=0.00036994 MUEO=0.91692524 MUEW=-0.018226 STMUEO=0.34067 THEMUO=2.5509 STTHEMUO=0.63756 CSO=2.0494 CSL=-0.97261 CSLEXP=0 CSW=0.044205 CSLW=-1.0021 STCSO=2.5545 THECSO=2 STTHECSO=0 XCORO=0.04872 XCORL=-0.27137 XCORW=-0.1948 XCORLW=0 STXCORO=1.1327 FETAO=1.0706 RSW1=321.598966 RSW2=-0.07 STRSO=-0.058157 RSBO=-0.0025425 RSGO=0.10986 THESATO=0.1 THESATL=0.446499 THESATLEXP=1.0973 THESATW=0.082797 THESATLW=-0.032897685 STTHESATO=0.48396 STTHESATL=0.50226 STTHESATW=0.049985 STTHESATLW=-0.059487 THESATBO=0.06 THESATGO=0.050814 AXO=8.7694 AXL=2.3029 ALPL=0.0019702 ALPLEXP=1.4003 ALPW=1.1052 ALP1L1=0.007475 ALP1LEXP=0.80983 ALP1L2=0.719 ALP1W=0.56703 ALP2L1=5.413e-07 ALP2LEXP=0.2541 ALP2L2=0 ALP2W=-10 VPO=0.06567 A1O=4.7288 A1L=0.052459 A1W=0.024056 A2O=22.013 STA2O=0.018532 A3O=1.2047 A3L=-0.10308 A3W=0.0069117 A4O=0.12894 A4L=-0.05413 A4W=-0.06197 GCOO=0 IGINVLW=0 IGOVW=0 IGOVDW=0 STIGO=2 GC2O=0.375 GC3O=0.063 CHIBO=3.1 AGIDLW=70 AGIDLDW=0 BGIDLO=13 BGIDLDO=41 STBGIDLO=-0.001067 STBGIDLDO=0 CGIDLO=0 CGIDLDO=0 CGBOVL=2.522e-16 CFRDW=0 FNTO=1 FNTEXCL=0 NFALW=1.42e+25 NFBLW=574300000 NFCLW=-3.015e-08 EFO=1 LINTNOI=-3.158e-08 ALPNOI=2.708 WEDGE=1e-08 WEDGEW=0 VFBEDGEO=-1 STVFBEDGEO=0.0005 STVFBEDGEL=0 STVFBEDGEW=0 STVFBEDGELW=0 DPHIBEDGEO=0 DPHIBEDGEL=0 DPHIBEDGELEXP=1 DPHIBEDGEW=0 DPHIBEDGELW=0 NSUBEDGEO=5e+23 NSUBEDGEL=0 NSUBEDGELEXP=1 NSUBEDGEW=0 NSUBEDGELW=0 CTEDGEO=0 CTEDGEL=0 CTEDGELEXP=1 FBETEDGE=0 LPEDGE=1e-08 BETEDGEW=0 STBETEDGEO=1 STBETEDGEL=0 STBETEDGEW=0 STBETEDGELW=0 PSCEEDGEL=0 PSCEEDGELEXP=2 PSCEEDGEW=0 PSCEBEDGEO=0 PSCEDEDGEO=0 CFEDGEL=0 CFEDGELEXP=2 CFEDGEW=0 CFDEDGEO=0 CFBEDGEO=0 FNTEDGEO=1 NFAEDGELW=8e+22 NFBEDGELW=30000000 NFCEDGELW=0 EFEDGEO=1 SAREF=1e-06 SBREF=1e-06 WLOD=0 KUO=0 KVSAT=0 TKUO=0 LKUO=0 WKUO=0 PKUO=0 LLODKUO=0 WLODKUO=0 KVTHO=0 LKVTHO=0 WKVTHO=0 PKVTHO=0 LLODVTH=0 WLODVTH=0 STETAO=0 LODETAO=1 SCREF=1e-06 WEB=0 WEC=0 KVTHOWEO=0 KVTHOWEL=0 KVTHOWEW=0 KVTHOWELW=0 KUOWEO=0 KUOWEL=0 KUOWEW=0 KUOWELW=0 TRJ=21 SWJUNEXP=0 IMAX=0.0020128 FREV=1000 CJORBOT=0.00085856 CJORSTI=2.4557e-11 CJORGAT=1.3846e-11 VBIRBOT=0.74373 VBIRSTI=1.597 VBIRGAT=0.6629 PBOT=0.27424 PSTI=0.16571 PGAT=0.1451 CJORBOTD=0.001 CJORSTID=1e-09 CJORGATD=1e-09 VBIRBOTD=1 VBIRSTID=1 VBIRGATD=1 PBOTD=0.5 PSTID=0.5 PGATD=0.5 PHIGBOT=1.1984 PHIGSTI=1.006 PHIGGAT=0.3 IDSATRBOT=5.397e-08 IDSATRSTI=4.0612e-15 IDSATRGAT=0 CSRHBOT=100 CSRHSTI=0.0001 CSRHGAT=0.0001 XJUNSTI=1.61e-08 XJUNGAT=6.134e-07 PHIGBOTD=1.16 PHIGSTID=1.16 PHIGGATD=1.16 IDSATRBOTD=1e-12 IDSATRSTID=1e-18 IDSATRGATD=1e-18 CSRHBOTD=100 CSRHSTID=0.0001 CSRHGATD=0.0001 XJUNSTID=1e-07 XJUNGATD=1e-07 CTATBOT=100 CTATSTI=0.0001 CTATGAT=0.0001 MEFFTATBOT=0.25 MEFFTATSTI=0.25 MEFFTATGAT=0.25 CTATBOTD=100 CTATSTID=0.0001 CTATGATD=0.0001 MEFFTATBOTD=0.25 MEFFTATSTID=0.25 MEFFTATGATD=0.25 CBBTBOT=1e-12 CBBTSTI=1e-21 CBBTGAT=1e-18 FBBTRBOT=1000000000 FBBTRSTI=1000000000 FBBTRGAT=1000000000 STFBBTBOT=-0.001 STFBBTSTI=-0.001 STFBBTGAT=-0.001 CBBTBOTD=1e-12 CBBTSTID=1e-18 CBBTGATD=1e-18 FBBTRBOTD=1000000000 FBBTRSTID=1000000000 FBBTRGATD=1000000000 STFBBTBOTD=-0.001 STFBBTSTID=-0.001 STFBBTGATD=-0.001 VBRBOT=10 VBRSTI=10 VBRGAT=10 PBRBOT=4 PBRSTI=4 PBRGAT=4 VBRBOTD=10 VBRSTID=10 VBRGATD=10 PBRBOTD=4 PBRSTID=4 PBRGATD=4 VJUNREF=2.5 FJUNQ=0.03 VJUNREFD=2.5 FJUNQD=0.03 RINT=3.0856e-12 RVPOLY=0 DLSIL=0 RSH=0 RSHD=0 CFRW=1.2e-16 RSHG=20 RGO=35 RBULKO=2000 RWELLO=2000 RJUNSO=2250 RJUNDO=2250 SWSOA=0 VGS_MAX=3 VGD_MAX=3 VGB_MAX=3 VDS_MAX=3 VDB_MAX=1.6 VSB_MAX=1.6
model hvn_w10338n_l2000n_ng2 PSP103VA TYPE=1 TR=27 DTA=0 SWGEO=1 SWIGATE=1 SWIMPACT=1 SWGIDL=0 SWJUNCAP=3 SWJUNASYM=0 SWNUD=0 SWEDGE=0 SWDELVTAC=0 SWIGN=1 QMC=1 LVARO=3.499e-08 LVARL=-0.09125 LVARW=0 LAP=6.3866e-08 WVARO=0 WVARL=0 WVARW=0 WOT=3e-08 DLQ=5.2202e-08 DWQ=3e-08 VFBO=-0.89839 VFBL=0.15096 VFBW=0.0017033 VFBLW=0.019398 STVFBO=0.0008739 STVFBL=0.00014864 STVFBW=-4.6174e-05 STVFBLW=-2.445e-06 ST2VFBO=0 TOXO=7.4256e-09 EPSROXO=3.9 NSUBO=1.8552e+23 NSUBW=-0.0050198 WSEG=1.098e-10 NPCK=3.178e+23 NPCKW=-2.7604 WSEGP=1e-08 LPCK=1e-08 LPCKW=0 FOL1=0.21033 FOL2=0.0026472 FACNEFFACO=1 FACNEFFACL=0 FACNEFFACW=0 FACNEFFACLW=0 GFACNUDO=1 GFACNUDL=0 GFACNUDLEXP=1 GFACNUDW=0 GFACNUDLW=0 VSBNUDO=0 DVSBNUDO=1 VNSUBO=0 NSLPO=0.05 DNSUBO=0.025686 DPHIBO=-0.0607576464 DPHIBL=-0.00546403785 DPHIBLEXP=2.3956 DPHIBW=0.014614 DPHIBLW=-0.017476272 DELVTACO=0 DELVTACL=0 DELVTACLEXP=1 DELVTACW=0 DELVTACLW=0 NPO=3.897e+26 NPL=-0.1215 TOXOVO=7.4256e-09 TOXOVDO=2e-09 LOV=6.3866e-08 LOVD=0 NOVO=5.5814e+24 NOVDO=5e+25 CTO=-0.061658 CTL=0.025 CTLEXP=1.6063 CTW=-0.044911 CTLW=-0.0077386 CTGO=0 CTBO=0 STCTO=1 CFL=0.0048288 CFLEXP=1.3328 CFW=0.037319 CFBO=0.26069 CFDO=0 PSCEL=0 PSCELEXP=2 PSCEW=0 PSCEBO=0 PSCEDO=0 UO=0.046687 FBET1=-0.35712 FBET1W=-0.14995 LP1=4.5615e-08 LP1W=0.4189 FBET2=-1.0245 LP2=9.42e-09 BETW1=0.6567 BETW2=-0.083639 WBET=1.0063e-10 STBETO=1.6942 STBETL=-0.0065587 STBETW=-0.060053 STBETLW=0.00036994 MUEO=0.91692524 MUEW=-0.018226 STMUEO=0.34067 THEMUO=2.5509 STTHEMUO=0.63756 CSO=2.0494 CSL=-0.97261 CSLEXP=0 CSW=0.044205 CSLW=-1.0021 STCSO=2.5545 THECSO=2 STTHECSO=0 XCORO=0.04872 XCORL=-0.27137 XCORW=-0.1948 XCORLW=0 STXCORO=1.1327 FETAO=1.0706 RSW1=321.598966 RSW2=-0.07 STRSO=-0.058157 RSBO=-0.0025425 RSGO=0.10986 THESATO=0.1 THESATL=0.446499 THESATLEXP=1.0973 THESATW=0.082797 THESATLW=-0.032897685 STTHESATO=0.48396 STTHESATL=0.50226 STTHESATW=0.049985 STTHESATLW=-0.059487 THESATBO=0.06 THESATGO=0.050814 AXO=8.7694 AXL=2.3029 ALPL=0.0019702 ALPLEXP=1.4003 ALPW=1.1052 ALP1L1=0.007475 ALP1LEXP=0.80983 ALP1L2=0.719 ALP1W=0.56703 ALP2L1=5.413e-07 ALP2LEXP=0.2541 ALP2L2=0 ALP2W=-10 VPO=0.06567 A1O=4.7288 A1L=0.052459 A1W=0.024056 A2O=22.013 STA2O=0.018532 A3O=1.2047 A3L=-0.10308 A3W=0.0069117 A4O=0.12894 A4L=-0.05413 A4W=-0.06197 GCOO=0 IGINVLW=0 IGOVW=0 IGOVDW=0 STIGO=2 GC2O=0.375 GC3O=0.063 CHIBO=3.1 AGIDLW=70 AGIDLDW=0 BGIDLO=13 BGIDLDO=41 STBGIDLO=-0.001067 STBGIDLDO=0 CGIDLO=0 CGIDLDO=0 CGBOVL=2.522e-16 CFRDW=0 FNTO=1 FNTEXCL=0 NFALW=1.42e+25 NFBLW=574300000 NFCLW=-3.015e-08 EFO=1 LINTNOI=-3.158e-08 ALPNOI=2.708 WEDGE=1e-08 WEDGEW=0 VFBEDGEO=-1 STVFBEDGEO=0.0005 STVFBEDGEL=0 STVFBEDGEW=0 STVFBEDGELW=0 DPHIBEDGEO=0 DPHIBEDGEL=0 DPHIBEDGELEXP=1 DPHIBEDGEW=0 DPHIBEDGELW=0 NSUBEDGEO=5e+23 NSUBEDGEL=0 NSUBEDGELEXP=1 NSUBEDGEW=0 NSUBEDGELW=0 CTEDGEO=0 CTEDGEL=0 CTEDGELEXP=1 FBETEDGE=0 LPEDGE=1e-08 BETEDGEW=0 STBETEDGEO=1 STBETEDGEL=0 STBETEDGEW=0 STBETEDGELW=0 PSCEEDGEL=0 PSCEEDGELEXP=2 PSCEEDGEW=0 PSCEBEDGEO=0 PSCEDEDGEO=0 CFEDGEL=0 CFEDGELEXP=2 CFEDGEW=0 CFDEDGEO=0 CFBEDGEO=0 FNTEDGEO=1 NFAEDGELW=8e+22 NFBEDGELW=30000000 NFCEDGELW=0 EFEDGEO=1 SAREF=1e-06 SBREF=1e-06 WLOD=0 KUO=0 KVSAT=0 TKUO=0 LKUO=0 WKUO=0 PKUO=0 LLODKUO=0 WLODKUO=0 KVTHO=0 LKVTHO=0 WKVTHO=0 PKVTHO=0 LLODVTH=0 WLODVTH=0 STETAO=0 LODETAO=1 SCREF=1e-06 WEB=0 WEC=0 KVTHOWEO=0 KVTHOWEL=0 KVTHOWEW=0 KVTHOWELW=0 KUOWEO=0 KUOWEL=0 KUOWEW=0 KUOWELW=0 TRJ=21 SWJUNEXP=0 IMAX=0.0020128 FREV=1000 CJORBOT=0.00085856 CJORSTI=2.4557e-11 CJORGAT=1.3846e-11 VBIRBOT=0.74373 VBIRSTI=1.597 VBIRGAT=0.6629 PBOT=0.27424 PSTI=0.16571 PGAT=0.1451 CJORBOTD=0.001 CJORSTID=1e-09 CJORGATD=1e-09 VBIRBOTD=1 VBIRSTID=1 VBIRGATD=1 PBOTD=0.5 PSTID=0.5 PGATD=0.5 PHIGBOT=1.1984 PHIGSTI=1.006 PHIGGAT=0.3 IDSATRBOT=5.397e-08 IDSATRSTI=4.0612e-15 IDSATRGAT=0 CSRHBOT=100 CSRHSTI=0.0001 CSRHGAT=0.0001 XJUNSTI=1.61e-08 XJUNGAT=6.134e-07 PHIGBOTD=1.16 PHIGSTID=1.16 PHIGGATD=1.16 IDSATRBOTD=1e-12 IDSATRSTID=1e-18 IDSATRGATD=1e-18 CSRHBOTD=100 CSRHSTID=0.0001 CSRHGATD=0.0001 XJUNSTID=1e-07 XJUNGATD=1e-07 CTATBOT=100 CTATSTI=0.0001 CTATGAT=0.0001 MEFFTATBOT=0.25 MEFFTATSTI=0.25 MEFFTATGAT=0.25 CTATBOTD=100 CTATSTID=0.0001 CTATGATD=0.0001 MEFFTATBOTD=0.25 MEFFTATSTID=0.25 MEFFTATGATD=0.25 CBBTBOT=1e-12 CBBTSTI=1e-21 CBBTGAT=1e-18 FBBTRBOT=1000000000 FBBTRSTI=1000000000 FBBTRGAT=1000000000 STFBBTBOT=-0.001 STFBBTSTI=-0.001 STFBBTGAT=-0.001 CBBTBOTD=1e-12 CBBTSTID=1e-18 CBBTGATD=1e-18 FBBTRBOTD=1000000000 FBBTRSTID=1000000000 FBBTRGATD=1000000000 STFBBTBOTD=-0.001 STFBBTSTID=-0.001 STFBBTGATD=-0.001 VBRBOT=10 VBRSTI=10 VBRGAT=10 PBRBOT=4 PBRSTI=4 PBRGAT=4 VBRBOTD=10 VBRSTID=10 VBRGATD=10 PBRBOTD=4 PBRSTID=4 PBRGATD=4 VJUNREF=2.5 FJUNQ=0.03 VJUNREFD=2.5 FJUNQD=0.03 RINT=3.0856e-12 RVPOLY=0 DLSIL=0 RSH=0 RSHD=0 CFRW=6e-17 RSHG=20 RGO=35 RBULKO=386.9230246 RWELLO=386.9230246 RJUNSO=967.3075615 RJUNDO=967.3075615 SWSOA=0 VGS_MAX=3 VGD_MAX=3 VGB_MAX=3 VDS_MAX=3 VDB_MAX=1.6 VSB_MAX=1.6
model hvn_w10876n_l2000n_ng2 PSP103VA TYPE=1 TR=27 DTA=0 SWGEO=1 SWIGATE=1 SWIMPACT=1 SWGIDL=0 SWJUNCAP=3 SWJUNASYM=0 SWNUD=0 SWEDGE=0 SWDELVTAC=0 SWIGN=1 QMC=1 LVARO=3.499e-08 LVARL=-0.09125 LVARW=0 LAP=6.3866e-08 WVARO=0 WVARL=0 WVARW=0 WOT=3e-08 DLQ=5.2202e-08 DWQ=3e-08 VFBO=-0.89839 VFBL=0.15096 VFBW=0.0017033 VFBLW=0.019398 STVFBO=0.0008739 STVFBL=0.00014864 STVFBW=-4.6174e-05 STVFBLW=-2.445e-06 ST2VFBO=0 TOXO=7.4256e-09 EPSROXO=3.9 NSUBO=1.8552e+23 NSUBW=-0.0050198 WSEG=1.098e-10 NPCK=3.178e+23 NPCKW=-2.7604 WSEGP=1e-08 LPCK=1e-08 LPCKW=0 FOL1=0.21033 FOL2=0.0026472 FACNEFFACO=1 FACNEFFACL=0 FACNEFFACW=0 FACNEFFACLW=0 GFACNUDO=1 GFACNUDL=0 GFACNUDLEXP=1 GFACNUDW=0 GFACNUDLW=0 VSBNUDO=0 DVSBNUDO=1 VNSUBO=0 NSLPO=0.05 DNSUBO=0.025686 DPHIBO=-0.0607576464 DPHIBL=-0.00546403785 DPHIBLEXP=2.3956 DPHIBW=0.014614 DPHIBLW=-0.017476272 DELVTACO=0 DELVTACL=0 DELVTACLEXP=1 DELVTACW=0 DELVTACLW=0 NPO=3.897e+26 NPL=-0.1215 TOXOVO=7.4256e-09 TOXOVDO=2e-09 LOV=6.3866e-08 LOVD=0 NOVO=5.5814e+24 NOVDO=5e+25 CTO=-0.061658 CTL=0.025 CTLEXP=1.6063 CTW=-0.044911 CTLW=-0.0077386 CTGO=0 CTBO=0 STCTO=1 CFL=0.0048288 CFLEXP=1.3328 CFW=0.037319 CFBO=0.26069 CFDO=0 PSCEL=0 PSCELEXP=2 PSCEW=0 PSCEBO=0 PSCEDO=0 UO=0.046687 FBET1=-0.35712 FBET1W=-0.14995 LP1=4.5615e-08 LP1W=0.4189 FBET2=-1.0245 LP2=9.42e-09 BETW1=0.6567 BETW2=-0.083639 WBET=1.0063e-10 STBETO=1.6942 STBETL=-0.0065587 STBETW=-0.060053 STBETLW=0.00036994 MUEO=0.91692524 MUEW=-0.018226 STMUEO=0.34067 THEMUO=2.5509 STTHEMUO=0.63756 CSO=2.0494 CSL=-0.97261 CSLEXP=0 CSW=0.044205 CSLW=-1.0021 STCSO=2.5545 THECSO=2 STTHECSO=0 XCORO=0.04872 XCORL=-0.27137 XCORW=-0.1948 XCORLW=0 STXCORO=1.1327 FETAO=1.0706 RSW1=321.598966 RSW2=-0.07 STRSO=-0.058157 RSBO=-0.0025425 RSGO=0.10986 THESATO=0.1 THESATL=0.446499 THESATLEXP=1.0973 THESATW=0.082797 THESATLW=-0.032897685 STTHESATO=0.48396 STTHESATL=0.50226 STTHESATW=0.049985 STTHESATLW=-0.059487 THESATBO=0.06 THESATGO=0.050814 AXO=8.7694 AXL=2.3029 ALPL=0.0019702 ALPLEXP=1.4003 ALPW=1.1052 ALP1L1=0.007475 ALP1LEXP=0.80983 ALP1L2=0.719 ALP1W=0.56703 ALP2L1=5.413e-07 ALP2LEXP=0.2541 ALP2L2=0 ALP2W=-10 VPO=0.06567 A1O=4.7288 A1L=0.052459 A1W=0.024056 A2O=22.013 STA2O=0.018532 A3O=1.2047 A3L=-0.10308 A3W=0.0069117 A4O=0.12894 A4L=-0.05413 A4W=-0.06197 GCOO=0 IGINVLW=0 IGOVW=0 IGOVDW=0 STIGO=2 GC2O=0.375 GC3O=0.063 CHIBO=3.1 AGIDLW=70 AGIDLDW=0 BGIDLO=13 BGIDLDO=41 STBGIDLO=-0.001067 STBGIDLDO=0 CGIDLO=0 CGIDLDO=0 CGBOVL=2.522e-16 CFRDW=0 FNTO=1 FNTEXCL=0 NFALW=1.42e+25 NFBLW=574300000 NFCLW=-3.015e-08 EFO=1 LINTNOI=-3.158e-08 ALPNOI=2.708 WEDGE=1e-08 WEDGEW=0 VFBEDGEO=-1 STVFBEDGEO=0.0005 STVFBEDGEL=0 STVFBEDGEW=0 STVFBEDGELW=0 DPHIBEDGEO=0 DPHIBEDGEL=0 DPHIBEDGELEXP=1 DPHIBEDGEW=0 DPHIBEDGELW=0 NSUBEDGEO=5e+23 NSUBEDGEL=0 NSUBEDGELEXP=1 NSUBEDGEW=0 NSUBEDGELW=0 CTEDGEO=0 CTEDGEL=0 CTEDGELEXP=1 FBETEDGE=0 LPEDGE=1e-08 BETEDGEW=0 STBETEDGEO=1 STBETEDGEL=0 STBETEDGEW=0 STBETEDGELW=0 PSCEEDGEL=0 PSCEEDGELEXP=2 PSCEEDGEW=0 PSCEBEDGEO=0 PSCEDEDGEO=0 CFEDGEL=0 CFEDGELEXP=2 CFEDGEW=0 CFDEDGEO=0 CFBEDGEO=0 FNTEDGEO=1 NFAEDGELW=8e+22 NFBEDGELW=30000000 NFCEDGELW=0 EFEDGEO=1 SAREF=1e-06 SBREF=1e-06 WLOD=0 KUO=0 KVSAT=0 TKUO=0 LKUO=0 WKUO=0 PKUO=0 LLODKUO=0 WLODKUO=0 KVTHO=0 LKVTHO=0 WKVTHO=0 PKVTHO=0 LLODVTH=0 WLODVTH=0 STETAO=0 LODETAO=1 SCREF=1e-06 WEB=0 WEC=0 KVTHOWEO=0 KVTHOWEL=0 KVTHOWEW=0 KVTHOWELW=0 KUOWEO=0 KUOWEL=0 KUOWEW=0 KUOWELW=0 TRJ=21 SWJUNEXP=0 IMAX=0.0020128 FREV=1000 CJORBOT=0.00085856 CJORSTI=2.4557e-11 CJORGAT=1.3846e-11 VBIRBOT=0.74373 VBIRSTI=1.597 VBIRGAT=0.6629 PBOT=0.27424 PSTI=0.16571 PGAT=0.1451 CJORBOTD=0.001 CJORSTID=1e-09 CJORGATD=1e-09 VBIRBOTD=1 VBIRSTID=1 VBIRGATD=1 PBOTD=0.5 PSTID=0.5 PGATD=0.5 PHIGBOT=1.1984 PHIGSTI=1.006 PHIGGAT=0.3 IDSATRBOT=5.397e-08 IDSATRSTI=4.0612e-15 IDSATRGAT=0 CSRHBOT=100 CSRHSTI=0.0001 CSRHGAT=0.0001 XJUNSTI=1.61e-08 XJUNGAT=6.134e-07 PHIGBOTD=1.16 PHIGSTID=1.16 PHIGGATD=1.16 IDSATRBOTD=1e-12 IDSATRSTID=1e-18 IDSATRGATD=1e-18 CSRHBOTD=100 CSRHSTID=0.0001 CSRHGATD=0.0001 XJUNSTID=1e-07 XJUNGATD=1e-07 CTATBOT=100 CTATSTI=0.0001 CTATGAT=0.0001 MEFFTATBOT=0.25 MEFFTATSTI=0.25 MEFFTATGAT=0.25 CTATBOTD=100 CTATSTID=0.0001 CTATGATD=0.0001 MEFFTATBOTD=0.25 MEFFTATSTID=0.25 MEFFTATGATD=0.25 CBBTBOT=1e-12 CBBTSTI=1e-21 CBBTGAT=1e-18 FBBTRBOT=1000000000 FBBTRSTI=1000000000 FBBTRGAT=1000000000 STFBBTBOT=-0.001 STFBBTSTI=-0.001 STFBBTGAT=-0.001 CBBTBOTD=1e-12 CBBTSTID=1e-18 CBBTGATD=1e-18 FBBTRBOTD=1000000000 FBBTRSTID=1000000000 FBBTRGATD=1000000000 STFBBTBOTD=-0.001 STFBBTSTID=-0.001 STFBBTGATD=-0.001 VBRBOT=10 VBRSTI=10 VBRGAT=10 PBRBOT=4 PBRSTI=4 PBRGAT=4 VBRBOTD=10 VBRSTID=10 VBRGATD=10 PBRBOTD=4 PBRSTID=4 PBRGATD=4 VJUNREF=2.5 FJUNQ=0.03 VJUNREFD=2.5 FJUNQD=0.03 RINT=3.0856e-12 RVPOLY=0 DLSIL=0 RSH=0 RSHD=0 CFRW=6e-17 RSHG=20 RGO=35 RBULKO=367.767977 RWELLO=367.767977 RJUNSO=919.4199426 RJUNDO=919.4199426 SWSOA=0 VGS_MAX=3 VGD_MAX=3 VGB_MAX=3 VDS_MAX=3 VDB_MAX=1.6 VSB_MAX=1.6
model hvn_w11318n_l2000n_ng2 PSP103VA TYPE=1 TR=27 DTA=0 SWGEO=1 SWIGATE=1 SWIMPACT=1 SWGIDL=0 SWJUNCAP=3 SWJUNASYM=0 SWNUD=0 SWEDGE=0 SWDELVTAC=0 SWIGN=1 QMC=1 LVARO=3.499e-08 LVARL=-0.09125 LVARW=0 LAP=6.3866e-08 WVARO=0 WVARL=0 WVARW=0 WOT=3e-08 DLQ=5.2202e-08 DWQ=3e-08 VFBO=-0.89839 VFBL=0.15096 VFBW=0.0017033 VFBLW=0.019398 STVFBO=0.0008739 STVFBL=0.00014864 STVFBW=-4.6174e-05 STVFBLW=-2.445e-06 ST2VFBO=0 TOXO=7.4256e-09 EPSROXO=3.9 NSUBO=1.8552e+23 NSUBW=-0.0050198 WSEG=1.098e-10 NPCK=3.178e+23 NPCKW=-2.7604 WSEGP=1e-08 LPCK=1e-08 LPCKW=0 FOL1=0.21033 FOL2=0.0026472 FACNEFFACO=1 FACNEFFACL=0 FACNEFFACW=0 FACNEFFACLW=0 GFACNUDO=1 GFACNUDL=0 GFACNUDLEXP=1 GFACNUDW=0 GFACNUDLW=0 VSBNUDO=0 DVSBNUDO=1 VNSUBO=0 NSLPO=0.05 DNSUBO=0.025686 DPHIBO=-0.0607576464 DPHIBL=-0.00546403785 DPHIBLEXP=2.3956 DPHIBW=0.014614 DPHIBLW=-0.017476272 DELVTACO=0 DELVTACL=0 DELVTACLEXP=1 DELVTACW=0 DELVTACLW=0 NPO=3.897e+26 NPL=-0.1215 TOXOVO=7.4256e-09 TOXOVDO=2e-09 LOV=6.3866e-08 LOVD=0 NOVO=5.5814e+24 NOVDO=5e+25 CTO=-0.061658 CTL=0.025 CTLEXP=1.6063 CTW=-0.044911 CTLW=-0.0077386 CTGO=0 CTBO=0 STCTO=1 CFL=0.0048288 CFLEXP=1.3328 CFW=0.037319 CFBO=0.26069 CFDO=0 PSCEL=0 PSCELEXP=2 PSCEW=0 PSCEBO=0 PSCEDO=0 UO=0.046687 FBET1=-0.35712 FBET1W=-0.14995 LP1=4.5615e-08 LP1W=0.4189 FBET2=-1.0245 LP2=9.42e-09 BETW1=0.6567 BETW2=-0.083639 WBET=1.0063e-10 STBETO=1.6942 STBETL=-0.0065587 STBETW=-0.060053 STBETLW=0.00036994 MUEO=0.91692524 MUEW=-0.018226 STMUEO=0.34067 THEMUO=2.5509 STTHEMUO=0.63756 CSO=2.0494 CSL=-0.97261 CSLEXP=0 CSW=0.044205 CSLW=-1.0021 STCSO=2.5545 THECSO=2 STTHECSO=0 XCORO=0.04872 XCORL=-0.27137 XCORW=-0.1948 XCORLW=0 STXCORO=1.1327 FETAO=1.0706 RSW1=321.598966 RSW2=-0.07 STRSO=-0.058157 RSBO=-0.0025425 RSGO=0.10986 THESATO=0.1 THESATL=0.446499 THESATLEXP=1.0973 THESATW=0.082797 THESATLW=-0.032897685 STTHESATO=0.48396 STTHESATL=0.50226 STTHESATW=0.049985 STTHESATLW=-0.059487 THESATBO=0.06 THESATGO=0.050814 AXO=8.7694 AXL=2.3029 ALPL=0.0019702 ALPLEXP=1.4003 ALPW=1.1052 ALP1L1=0.007475 ALP1LEXP=0.80983 ALP1L2=0.719 ALP1W=0.56703 ALP2L1=5.413e-07 ALP2LEXP=0.2541 ALP2L2=0 ALP2W=-10 VPO=0.06567 A1O=4.7288 A1L=0.052459 A1W=0.024056 A2O=22.013 STA2O=0.018532 A3O=1.2047 A3L=-0.10308 A3W=0.0069117 A4O=0.12894 A4L=-0.05413 A4W=-0.06197 GCOO=0 IGINVLW=0 IGOVW=0 IGOVDW=0 STIGO=2 GC2O=0.375 GC3O=0.063 CHIBO=3.1 AGIDLW=70 AGIDLDW=0 BGIDLO=13 BGIDLDO=41 STBGIDLO=-0.001067 STBGIDLDO=0 CGIDLO=0 CGIDLDO=0 CGBOVL=2.522e-16 CFRDW=0 FNTO=1 FNTEXCL=0 NFALW=1.42e+25 NFBLW=574300000 NFCLW=-3.015e-08 EFO=1 LINTNOI=-3.158e-08 ALPNOI=2.708 WEDGE=1e-08 WEDGEW=0 VFBEDGEO=-1 STVFBEDGEO=0.0005 STVFBEDGEL=0 STVFBEDGEW=0 STVFBEDGELW=0 DPHIBEDGEO=0 DPHIBEDGEL=0 DPHIBEDGELEXP=1 DPHIBEDGEW=0 DPHIBEDGELW=0 NSUBEDGEO=5e+23 NSUBEDGEL=0 NSUBEDGELEXP=1 NSUBEDGEW=0 NSUBEDGELW=0 CTEDGEO=0 CTEDGEL=0 CTEDGELEXP=1 FBETEDGE=0 LPEDGE=1e-08 BETEDGEW=0 STBETEDGEO=1 STBETEDGEL=0 STBETEDGEW=0 STBETEDGELW=0 PSCEEDGEL=0 PSCEEDGELEXP=2 PSCEEDGEW=0 PSCEBEDGEO=0 PSCEDEDGEO=0 CFEDGEL=0 CFEDGELEXP=2 CFEDGEW=0 CFDEDGEO=0 CFBEDGEO=0 FNTEDGEO=1 NFAEDGELW=8e+22 NFBEDGELW=30000000 NFCEDGELW=0 EFEDGEO=1 SAREF=1e-06 SBREF=1e-06 WLOD=0 KUO=0 KVSAT=0 TKUO=0 LKUO=0 WKUO=0 PKUO=0 LLODKUO=0 WLODKUO=0 KVTHO=0 LKVTHO=0 WKVTHO=0 PKVTHO=0 LLODVTH=0 WLODVTH=0 STETAO=0 LODETAO=1 SCREF=1e-06 WEB=0 WEC=0 KVTHOWEO=0 KVTHOWEL=0 KVTHOWEW=0 KVTHOWELW=0 KUOWEO=0 KUOWEL=0 KUOWEW=0 KUOWELW=0 TRJ=21 SWJUNEXP=0 IMAX=0.0020128 FREV=1000 CJORBOT=0.00085856 CJORSTI=2.4557e-11 CJORGAT=1.3846e-11 VBIRBOT=0.74373 VBIRSTI=1.597 VBIRGAT=0.6629 PBOT=0.27424 PSTI=0.16571 PGAT=0.1451 CJORBOTD=0.001 CJORSTID=1e-09 CJORGATD=1e-09 VBIRBOTD=1 VBIRSTID=1 VBIRGATD=1 PBOTD=0.5 PSTID=0.5 PGATD=0.5 PHIGBOT=1.1984 PHIGSTI=1.006 PHIGGAT=0.3 IDSATRBOT=5.397e-08 IDSATRSTI=4.0612e-15 IDSATRGAT=0 CSRHBOT=100 CSRHSTI=0.0001 CSRHGAT=0.0001 XJUNSTI=1.61e-08 XJUNGAT=6.134e-07 PHIGBOTD=1.16 PHIGSTID=1.16 PHIGGATD=1.16 IDSATRBOTD=1e-12 IDSATRSTID=1e-18 IDSATRGATD=1e-18 CSRHBOTD=100 CSRHSTID=0.0001 CSRHGATD=0.0001 XJUNSTID=1e-07 XJUNGATD=1e-07 CTATBOT=100 CTATSTI=0.0001 CTATGAT=0.0001 MEFFTATBOT=0.25 MEFFTATSTI=0.25 MEFFTATGAT=0.25 CTATBOTD=100 CTATSTID=0.0001 CTATGATD=0.0001 MEFFTATBOTD=0.25 MEFFTATSTID=0.25 MEFFTATGATD=0.25 CBBTBOT=1e-12 CBBTSTI=1e-21 CBBTGAT=1e-18 FBBTRBOT=1000000000 FBBTRSTI=1000000000 FBBTRGAT=1000000000 STFBBTBOT=-0.001 STFBBTSTI=-0.001 STFBBTGAT=-0.001 CBBTBOTD=1e-12 CBBTSTID=1e-18 CBBTGATD=1e-18 FBBTRBOTD=1000000000 FBBTRSTID=1000000000 FBBTRGATD=1000000000 STFBBTBOTD=-0.001 STFBBTSTID=-0.001 STFBBTGATD=-0.001 VBRBOT=10 VBRSTI=10 VBRGAT=10 PBRBOT=4 PBRSTI=4 PBRGAT=4 VBRBOTD=10 VBRSTID=10 VBRGATD=10 PBRBOTD=4 PBRSTID=4 PBRGATD=4 VJUNREF=2.5 FJUNQ=0.03 VJUNREFD=2.5 FJUNQD=0.03 RINT=3.0856e-12 RVPOLY=0 DLSIL=0 RSH=0 RSHD=0 CFRW=6e-17 RSHG=20 RGO=35 RBULKO=353.4315247 RWELLO=353.4315247 RJUNSO=883.5788116 RJUNDO=883.5788116 SWSOA=0 VGS_MAX=3 VGD_MAX=3 VGB_MAX=3 VDS_MAX=3 VDB_MAX=1.6 VSB_MAX=1.6
model hvn_w12000n_l2000n_ng2 PSP103VA TYPE=1 TR=27 DTA=0 SWGEO=1 SWIGATE=1 SWIMPACT=1 SWGIDL=0 SWJUNCAP=3 SWJUNASYM=0 SWNUD=0 SWEDGE=0 SWDELVTAC=0 SWIGN=1 QMC=1 LVARO=3.499e-08 LVARL=-0.09125 LVARW=0 LAP=6.3866e-08 WVARO=0 WVARL=0 WVARW=0 WOT=3e-08 DLQ=5.2202e-08 DWQ=3e-08 VFBO=-0.89839 VFBL=0.15096 VFBW=0.0017033 VFBLW=0.019398 STVFBO=0.0008739 STVFBL=0.00014864 STVFBW=-4.6174e-05 STVFBLW=-2.445e-06 ST2VFBO=0 TOXO=7.4256e-09 EPSROXO=3.9 NSUBO=1.8552e+23 NSUBW=-0.0050198 WSEG=1.098e-10 NPCK=3.178e+23 NPCKW=-2.7604 WSEGP=1e-08 LPCK=1e-08 LPCKW=0 FOL1=0.21033 FOL2=0.0026472 FACNEFFACO=1 FACNEFFACL=0 FACNEFFACW=0 FACNEFFACLW=0 GFACNUDO=1 GFACNUDL=0 GFACNUDLEXP=1 GFACNUDW=0 GFACNUDLW=0 VSBNUDO=0 DVSBNUDO=1 VNSUBO=0 NSLPO=0.05 DNSUBO=0.025686 DPHIBO=-0.0607576464 DPHIBL=-0.00546403785 DPHIBLEXP=2.3956 DPHIBW=0.014614 DPHIBLW=-0.017476272 DELVTACO=0 DELVTACL=0 DELVTACLEXP=1 DELVTACW=0 DELVTACLW=0 NPO=3.897e+26 NPL=-0.1215 TOXOVO=7.4256e-09 TOXOVDO=2e-09 LOV=6.3866e-08 LOVD=0 NOVO=5.5814e+24 NOVDO=5e+25 CTO=-0.061658 CTL=0.025 CTLEXP=1.6063 CTW=-0.044911 CTLW=-0.0077386 CTGO=0 CTBO=0 STCTO=1 CFL=0.0048288 CFLEXP=1.3328 CFW=0.037319 CFBO=0.26069 CFDO=0 PSCEL=0 PSCELEXP=2 PSCEW=0 PSCEBO=0 PSCEDO=0 UO=0.046687 FBET1=-0.35712 FBET1W=-0.14995 LP1=4.5615e-08 LP1W=0.4189 FBET2=-1.0245 LP2=9.42e-09 BETW1=0.6567 BETW2=-0.083639 WBET=1.0063e-10 STBETO=1.6942 STBETL=-0.0065587 STBETW=-0.060053 STBETLW=0.00036994 MUEO=0.91692524 MUEW=-0.018226 STMUEO=0.34067 THEMUO=2.5509 STTHEMUO=0.63756 CSO=2.0494 CSL=-0.97261 CSLEXP=0 CSW=0.044205 CSLW=-1.0021 STCSO=2.5545 THECSO=2 STTHECSO=0 XCORO=0.04872 XCORL=-0.27137 XCORW=-0.1948 XCORLW=0 STXCORO=1.1327 FETAO=1.0706 RSW1=321.598966 RSW2=-0.07 STRSO=-0.058157 RSBO=-0.0025425 RSGO=0.10986 THESATO=0.1 THESATL=0.446499 THESATLEXP=1.0973 THESATW=0.082797 THESATLW=-0.032897685 STTHESATO=0.48396 STTHESATL=0.50226 STTHESATW=0.049985 STTHESATLW=-0.059487 THESATBO=0.06 THESATGO=0.050814 AXO=8.7694 AXL=2.3029 ALPL=0.0019702 ALPLEXP=1.4003 ALPW=1.1052 ALP1L1=0.007475 ALP1LEXP=0.80983 ALP1L2=0.719 ALP1W=0.56703 ALP2L1=5.413e-07 ALP2LEXP=0.2541 ALP2L2=0 ALP2W=-10 VPO=0.06567 A1O=4.7288 A1L=0.052459 A1W=0.024056 A2O=22.013 STA2O=0.018532 A3O=1.2047 A3L=-0.10308 A3W=0.0069117 A4O=0.12894 A4L=-0.05413 A4W=-0.06197 GCOO=0 IGINVLW=0 IGOVW=0 IGOVDW=0 STIGO=2 GC2O=0.375 GC3O=0.063 CHIBO=3.1 AGIDLW=70 AGIDLDW=0 BGIDLO=13 BGIDLDO=41 STBGIDLO=-0.001067 STBGIDLDO=0 CGIDLO=0 CGIDLDO=0 CGBOVL=2.522e-16 CFRDW=0 FNTO=1 FNTEXCL=0 NFALW=1.42e+25 NFBLW=574300000 NFCLW=-3.015e-08 EFO=1 LINTNOI=-3.158e-08 ALPNOI=2.708 WEDGE=1e-08 WEDGEW=0 VFBEDGEO=-1 STVFBEDGEO=0.0005 STVFBEDGEL=0 STVFBEDGEW=0 STVFBEDGELW=0 DPHIBEDGEO=0 DPHIBEDGEL=0 DPHIBEDGELEXP=1 DPHIBEDGEW=0 DPHIBEDGELW=0 NSUBEDGEO=5e+23 NSUBEDGEL=0 NSUBEDGELEXP=1 NSUBEDGEW=0 NSUBEDGELW=0 CTEDGEO=0 CTEDGEL=0 CTEDGELEXP=1 FBETEDGE=0 LPEDGE=1e-08 BETEDGEW=0 STBETEDGEO=1 STBETEDGEL=0 STBETEDGEW=0 STBETEDGELW=0 PSCEEDGEL=0 PSCEEDGELEXP=2 PSCEEDGEW=0 PSCEBEDGEO=0 PSCEDEDGEO=0 CFEDGEL=0 CFEDGELEXP=2 CFEDGEW=0 CFDEDGEO=0 CFBEDGEO=0 FNTEDGEO=1 NFAEDGELW=8e+22 NFBEDGELW=30000000 NFCEDGELW=0 EFEDGEO=1 SAREF=1e-06 SBREF=1e-06 WLOD=0 KUO=0 KVSAT=0 TKUO=0 LKUO=0 WKUO=0 PKUO=0 LLODKUO=0 WLODKUO=0 KVTHO=0 LKVTHO=0 WKVTHO=0 PKVTHO=0 LLODVTH=0 WLODVTH=0 STETAO=0 LODETAO=1 SCREF=1e-06 WEB=0 WEC=0 KVTHOWEO=0 KVTHOWEL=0 KVTHOWEW=0 KVTHOWELW=0 KUOWEO=0 KUOWEL=0 KUOWEW=0 KUOWELW=0 TRJ=21 SWJUNEXP=0 IMAX=0.0020128 FREV=1000 CJORBOT=0.00085856 CJORSTI=2.4557e-11 CJORGAT=1.3846e-11 VBIRBOT=0.74373 VBIRSTI=1.597 VBIRGAT=0.6629 PBOT=0.27424 PSTI=0.16571 PGAT=0.1451 CJORBOTD=0.001 CJORSTID=1e-09 CJORGATD=1e-09 VBIRBOTD=1 VBIRSTID=1 VBIRGATD=1 PBOTD=0.5 PSTID=0.5 PGATD=0.5 PHIGBOT=1.1984 PHIGSTI=1.006 PHIGGAT=0.3 IDSATRBOT=5.397e-08 IDSATRSTI=4.0612e-15 IDSATRGAT=0 CSRHBOT=100 CSRHSTI=0.0001 CSRHGAT=0.0001 XJUNSTI=1.61e-08 XJUNGAT=6.134e-07 PHIGBOTD=1.16 PHIGSTID=1.16 PHIGGATD=1.16 IDSATRBOTD=1e-12 IDSATRSTID=1e-18 IDSATRGATD=1e-18 CSRHBOTD=100 CSRHSTID=0.0001 CSRHGATD=0.0001 XJUNSTID=1e-07 XJUNGATD=1e-07 CTATBOT=100 CTATSTI=0.0001 CTATGAT=0.0001 MEFFTATBOT=0.25 MEFFTATSTI=0.25 MEFFTATGAT=0.25 CTATBOTD=100 CTATSTID=0.0001 CTATGATD=0.0001 MEFFTATBOTD=0.25 MEFFTATSTID=0.25 MEFFTATGATD=0.25 CBBTBOT=1e-12 CBBTSTI=1e-21 CBBTGAT=1e-18 FBBTRBOT=1000000000 FBBTRSTI=1000000000 FBBTRGAT=1000000000 STFBBTBOT=-0.001 STFBBTSTI=-0.001 STFBBTGAT=-0.001 CBBTBOTD=1e-12 CBBTSTID=1e-18 CBBTGATD=1e-18 FBBTRBOTD=1000000000 FBBTRSTID=1000000000 FBBTRGATD=1000000000 STFBBTBOTD=-0.001 STFBBTSTID=-0.001 STFBBTGATD=-0.001 VBRBOT=10 VBRSTI=10 VBRGAT=10 PBRBOT=4 PBRSTI=4 PBRGAT=4 VBRBOTD=10 VBRSTID=10 VBRGATD=10 PBRBOTD=4 PBRSTID=4 PBRGATD=4 VJUNREF=2.5 FJUNQ=0.03 VJUNREFD=2.5 FJUNQD=0.03 RINT=3.0856e-12 RVPOLY=0 DLSIL=0 RSH=0 RSHD=0 CFRW=6e-17 RSHG=20 RGO=35 RBULKO=333.3333333 RWELLO=333.3333333 RJUNSO=833.3333333 RJUNDO=833.3333333 SWSOA=0 VGS_MAX=3 VGD_MAX=3 VGB_MAX=3 VDS_MAX=3 VDB_MAX=1.6 VSB_MAX=1.6
model hvn_w17050n_l2000n_ng2 PSP103VA TYPE=1 TR=27 DTA=0 SWGEO=1 SWIGATE=1 SWIMPACT=1 SWGIDL=0 SWJUNCAP=3 SWJUNASYM=0 SWNUD=0 SWEDGE=0 SWDELVTAC=0 SWIGN=1 QMC=1 LVARO=3.499e-08 LVARL=-0.09125 LVARW=0 LAP=6.3866e-08 WVARO=0 WVARL=0 WVARW=0 WOT=3e-08 DLQ=5.2202e-08 DWQ=3e-08 VFBO=-0.89839 VFBL=0.15096 VFBW=0.0017033 VFBLW=0.019398 STVFBO=0.0008739 STVFBL=0.00014864 STVFBW=-4.6174e-05 STVFBLW=-2.445e-06 ST2VFBO=0 TOXO=7.4256e-09 EPSROXO=3.9 NSUBO=1.8552e+23 NSUBW=-0.0050198 WSEG=1.098e-10 NPCK=3.178e+23 NPCKW=-2.7604 WSEGP=1e-08 LPCK=1e-08 LPCKW=0 FOL1=0.21033 FOL2=0.0026472 FACNEFFACO=1 FACNEFFACL=0 FACNEFFACW=0 FACNEFFACLW=0 GFACNUDO=1 GFACNUDL=0 GFACNUDLEXP=1 GFACNUDW=0 GFACNUDLW=0 VSBNUDO=0 DVSBNUDO=1 VNSUBO=0 NSLPO=0.05 DNSUBO=0.025686 DPHIBO=-0.0607576464 DPHIBL=-0.00546403785 DPHIBLEXP=2.3956 DPHIBW=0.014614 DPHIBLW=-0.017476272 DELVTACO=0 DELVTACL=0 DELVTACLEXP=1 DELVTACW=0 DELVTACLW=0 NPO=3.897e+26 NPL=-0.1215 TOXOVO=7.4256e-09 TOXOVDO=2e-09 LOV=6.3866e-08 LOVD=0 NOVO=5.5814e+24 NOVDO=5e+25 CTO=-0.061658 CTL=0.025 CTLEXP=1.6063 CTW=-0.044911 CTLW=-0.0077386 CTGO=0 CTBO=0 STCTO=1 CFL=0.0048288 CFLEXP=1.3328 CFW=0.037319 CFBO=0.26069 CFDO=0 PSCEL=0 PSCELEXP=2 PSCEW=0 PSCEBO=0 PSCEDO=0 UO=0.046687 FBET1=-0.35712 FBET1W=-0.14995 LP1=4.5615e-08 LP1W=0.4189 FBET2=-1.0245 LP2=9.42e-09 BETW1=0.6567 BETW2=-0.083639 WBET=1.0063e-10 STBETO=1.6942 STBETL=-0.0065587 STBETW=-0.060053 STBETLW=0.00036994 MUEO=0.91692524 MUEW=-0.018226 STMUEO=0.34067 THEMUO=2.5509 STTHEMUO=0.63756 CSO=2.0494 CSL=-0.97261 CSLEXP=0 CSW=0.044205 CSLW=-1.0021 STCSO=2.5545 THECSO=2 STTHECSO=0 XCORO=0.04872 XCORL=-0.27137 XCORW=-0.1948 XCORLW=0 STXCORO=1.1327 FETAO=1.0706 RSW1=321.598966 RSW2=-0.07 STRSO=-0.058157 RSBO=-0.0025425 RSGO=0.10986 THESATO=0.1 THESATL=0.446499 THESATLEXP=1.0973 THESATW=0.082797 THESATLW=-0.032897685 STTHESATO=0.48396 STTHESATL=0.50226 STTHESATW=0.049985 STTHESATLW=-0.059487 THESATBO=0.06 THESATGO=0.050814 AXO=8.7694 AXL=2.3029 ALPL=0.0019702 ALPLEXP=1.4003 ALPW=1.1052 ALP1L1=0.007475 ALP1LEXP=0.80983 ALP1L2=0.719 ALP1W=0.56703 ALP2L1=5.413e-07 ALP2LEXP=0.2541 ALP2L2=0 ALP2W=-10 VPO=0.06567 A1O=4.7288 A1L=0.052459 A1W=0.024056 A2O=22.013 STA2O=0.018532 A3O=1.2047 A3L=-0.10308 A3W=0.0069117 A4O=0.12894 A4L=-0.05413 A4W=-0.06197 GCOO=0 IGINVLW=0 IGOVW=0 IGOVDW=0 STIGO=2 GC2O=0.375 GC3O=0.063 CHIBO=3.1 AGIDLW=70 AGIDLDW=0 BGIDLO=13 BGIDLDO=41 STBGIDLO=-0.001067 STBGIDLDO=0 CGIDLO=0 CGIDLDO=0 CGBOVL=2.522e-16 CFRDW=0 FNTO=1 FNTEXCL=0 NFALW=1.42e+25 NFBLW=574300000 NFCLW=-3.015e-08 EFO=1 LINTNOI=-3.158e-08 ALPNOI=2.708 WEDGE=1e-08 WEDGEW=0 VFBEDGEO=-1 STVFBEDGEO=0.0005 STVFBEDGEL=0 STVFBEDGEW=0 STVFBEDGELW=0 DPHIBEDGEO=0 DPHIBEDGEL=0 DPHIBEDGELEXP=1 DPHIBEDGEW=0 DPHIBEDGELW=0 NSUBEDGEO=5e+23 NSUBEDGEL=0 NSUBEDGELEXP=1 NSUBEDGEW=0 NSUBEDGELW=0 CTEDGEO=0 CTEDGEL=0 CTEDGELEXP=1 FBETEDGE=0 LPEDGE=1e-08 BETEDGEW=0 STBETEDGEO=1 STBETEDGEL=0 STBETEDGEW=0 STBETEDGELW=0 PSCEEDGEL=0 PSCEEDGELEXP=2 PSCEEDGEW=0 PSCEBEDGEO=0 PSCEDEDGEO=0 CFEDGEL=0 CFEDGELEXP=2 CFEDGEW=0 CFDEDGEO=0 CFBEDGEO=0 FNTEDGEO=1 NFAEDGELW=8e+22 NFBEDGELW=30000000 NFCEDGELW=0 EFEDGEO=1 SAREF=1e-06 SBREF=1e-06 WLOD=0 KUO=0 KVSAT=0 TKUO=0 LKUO=0 WKUO=0 PKUO=0 LLODKUO=0 WLODKUO=0 KVTHO=0 LKVTHO=0 WKVTHO=0 PKVTHO=0 LLODVTH=0 WLODVTH=0 STETAO=0 LODETAO=1 SCREF=1e-06 WEB=0 WEC=0 KVTHOWEO=0 KVTHOWEL=0 KVTHOWEW=0 KVTHOWELW=0 KUOWEO=0 KUOWEL=0 KUOWEW=0 KUOWELW=0 TRJ=21 SWJUNEXP=0 IMAX=0.0020128 FREV=1000 CJORBOT=0.00085856 CJORSTI=2.4557e-11 CJORGAT=1.3846e-11 VBIRBOT=0.74373 VBIRSTI=1.597 VBIRGAT=0.6629 PBOT=0.27424 PSTI=0.16571 PGAT=0.1451 CJORBOTD=0.001 CJORSTID=1e-09 CJORGATD=1e-09 VBIRBOTD=1 VBIRSTID=1 VBIRGATD=1 PBOTD=0.5 PSTID=0.5 PGATD=0.5 PHIGBOT=1.1984 PHIGSTI=1.006 PHIGGAT=0.3 IDSATRBOT=5.397e-08 IDSATRSTI=4.0612e-15 IDSATRGAT=0 CSRHBOT=100 CSRHSTI=0.0001 CSRHGAT=0.0001 XJUNSTI=1.61e-08 XJUNGAT=6.134e-07 PHIGBOTD=1.16 PHIGSTID=1.16 PHIGGATD=1.16 IDSATRBOTD=1e-12 IDSATRSTID=1e-18 IDSATRGATD=1e-18 CSRHBOTD=100 CSRHSTID=0.0001 CSRHGATD=0.0001 XJUNSTID=1e-07 XJUNGATD=1e-07 CTATBOT=100 CTATSTI=0.0001 CTATGAT=0.0001 MEFFTATBOT=0.25 MEFFTATSTI=0.25 MEFFTATGAT=0.25 CTATBOTD=100 CTATSTID=0.0001 CTATGATD=0.0001 MEFFTATBOTD=0.25 MEFFTATSTID=0.25 MEFFTATGATD=0.25 CBBTBOT=1e-12 CBBTSTI=1e-21 CBBTGAT=1e-18 FBBTRBOT=1000000000 FBBTRSTI=1000000000 FBBTRGAT=1000000000 STFBBTBOT=-0.001 STFBBTSTI=-0.001 STFBBTGAT=-0.001 CBBTBOTD=1e-12 CBBTSTID=1e-18 CBBTGATD=1e-18 FBBTRBOTD=1000000000 FBBTRSTID=1000000000 FBBTRGATD=1000000000 STFBBTBOTD=-0.001 STFBBTSTID=-0.001 STFBBTGATD=-0.001 VBRBOT=10 VBRSTI=10 VBRGAT=10 PBRBOT=4 PBRSTI=4 PBRGAT=4 VBRBOTD=10 VBRSTID=10 VBRGATD=10 PBRBOTD=4 PBRSTID=4 PBRGATD=4 VJUNREF=2.5 FJUNQ=0.03 VJUNREFD=2.5 FJUNQD=0.03 RINT=3.0856e-12 RVPOLY=0 DLSIL=0 RSH=0 RSHD=0 CFRW=6e-17 RSHG=20 RGO=35 RBULKO=234.5984 RWELLO=234.5984 RJUNSO=586.496 RJUNDO=586.496 SWSOA=0 VGS_MAX=3 VGD_MAX=3 VGB_MAX=3 VDS_MAX=3 VDB_MAX=1.6 VSB_MAX=1.6
model hvn_w17050n_l450n_ng2 PSP103VA TYPE=1 TR=27 DTA=0 SWGEO=1 SWIGATE=1 SWIMPACT=1 SWGIDL=0 SWJUNCAP=3 SWJUNASYM=0 SWNUD=0 SWEDGE=0 SWDELVTAC=0 SWIGN=1 QMC=1 LVARO=3.499e-08 LVARL=-0.09125 LVARW=0 LAP=6.3866e-08 WVARO=0 WVARL=0 WVARW=0 WOT=3e-08 DLQ=5.2202e-08 DWQ=3e-08 VFBO=-0.89839 VFBL=0.15096 VFBW=0.0017033 VFBLW=0.019398 STVFBO=0.0008739 STVFBL=0.00014864 STVFBW=-4.6174e-05 STVFBLW=-2.445e-06 ST2VFBO=0 TOXO=7.4256e-09 EPSROXO=3.9 NSUBO=1.8552e+23 NSUBW=-0.0050198 WSEG=1.098e-10 NPCK=3.178e+23 NPCKW=-2.7604 WSEGP=1e-08 LPCK=1e-08 LPCKW=0 FOL1=0.21033 FOL2=0.0026472 FACNEFFACO=1 FACNEFFACL=0 FACNEFFACW=0 FACNEFFACLW=0 GFACNUDO=1 GFACNUDL=0 GFACNUDLEXP=1 GFACNUDW=0 GFACNUDLW=0 VSBNUDO=0 DVSBNUDO=1 VNSUBO=0 NSLPO=0.05 DNSUBO=0.025686 DPHIBO=-0.0607576464 DPHIBL=-0.00546403785 DPHIBLEXP=2.3956 DPHIBW=0.014614 DPHIBLW=-0.017476272 DELVTACO=0 DELVTACL=0 DELVTACLEXP=1 DELVTACW=0 DELVTACLW=0 NPO=3.897e+26 NPL=-0.1215 TOXOVO=7.4256e-09 TOXOVDO=2e-09 LOV=6.3866e-08 LOVD=0 NOVO=5.5814e+24 NOVDO=5e+25 CTO=-0.061658 CTL=0.025 CTLEXP=1.6063 CTW=-0.044911 CTLW=-0.0077386 CTGO=0 CTBO=0 STCTO=1 CFL=0.0048288 CFLEXP=1.3328 CFW=0.037319 CFBO=0.26069 CFDO=0 PSCEL=0 PSCELEXP=2 PSCEW=0 PSCEBO=0 PSCEDO=0 UO=0.046687 FBET1=-0.35712 FBET1W=-0.14995 LP1=4.5615e-08 LP1W=0.4189 FBET2=-1.0245 LP2=9.42e-09 BETW1=0.6567 BETW2=-0.083639 WBET=1.0063e-10 STBETO=1.6942 STBETL=-0.0065587 STBETW=-0.060053 STBETLW=0.00036994 MUEO=0.91692524 MUEW=-0.018226 STMUEO=0.34067 THEMUO=2.5509 STTHEMUO=0.63756 CSO=2.0494 CSL=-0.97261 CSLEXP=0 CSW=0.044205 CSLW=-1.0021 STCSO=2.5545 THECSO=2 STTHECSO=0 XCORO=0.04872 XCORL=-0.27137 XCORW=-0.1948 XCORLW=0 STXCORO=1.1327 FETAO=1.0706 RSW1=321.598966 RSW2=-0.07 STRSO=-0.058157 RSBO=-0.0025425 RSGO=0.10986 THESATO=0.1 THESATL=0.446499 THESATLEXP=1.0973 THESATW=0.082797 THESATLW=-0.032897685 STTHESATO=0.48396 STTHESATL=0.50226 STTHESATW=0.049985 STTHESATLW=-0.059487 THESATBO=0.06 THESATGO=0.050814 AXO=8.7694 AXL=2.3029 ALPL=0.0019702 ALPLEXP=1.4003 ALPW=1.1052 ALP1L1=0.007475 ALP1LEXP=0.80983 ALP1L2=0.719 ALP1W=0.56703 ALP2L1=5.413e-07 ALP2LEXP=0.2541 ALP2L2=0 ALP2W=-10 VPO=0.06567 A1O=4.7288 A1L=0.052459 A1W=0.024056 A2O=22.013 STA2O=0.018532 A3O=1.2047 A3L=-0.10308 A3W=0.0069117 A4O=0.12894 A4L=-0.05413 A4W=-0.06197 GCOO=0 IGINVLW=0 IGOVW=0 IGOVDW=0 STIGO=2 GC2O=0.375 GC3O=0.063 CHIBO=3.1 AGIDLW=70 AGIDLDW=0 BGIDLO=13 BGIDLDO=41 STBGIDLO=-0.001067 STBGIDLDO=0 CGIDLO=0 CGIDLDO=0 CGBOVL=2.522e-16 CFRDW=0 FNTO=1 FNTEXCL=0 NFALW=1.42e+25 NFBLW=574300000 NFCLW=-3.015e-08 EFO=1 LINTNOI=-3.158e-08 ALPNOI=2.708 WEDGE=1e-08 WEDGEW=0 VFBEDGEO=-1 STVFBEDGEO=0.0005 STVFBEDGEL=0 STVFBEDGEW=0 STVFBEDGELW=0 DPHIBEDGEO=0 DPHIBEDGEL=0 DPHIBEDGELEXP=1 DPHIBEDGEW=0 DPHIBEDGELW=0 NSUBEDGEO=5e+23 NSUBEDGEL=0 NSUBEDGELEXP=1 NSUBEDGEW=0 NSUBEDGELW=0 CTEDGEO=0 CTEDGEL=0 CTEDGELEXP=1 FBETEDGE=0 LPEDGE=1e-08 BETEDGEW=0 STBETEDGEO=1 STBETEDGEL=0 STBETEDGEW=0 STBETEDGELW=0 PSCEEDGEL=0 PSCEEDGELEXP=2 PSCEEDGEW=0 PSCEBEDGEO=0 PSCEDEDGEO=0 CFEDGEL=0 CFEDGELEXP=2 CFEDGEW=0 CFDEDGEO=0 CFBEDGEO=0 FNTEDGEO=1 NFAEDGELW=8e+22 NFBEDGELW=30000000 NFCEDGELW=0 EFEDGEO=1 SAREF=1e-06 SBREF=1e-06 WLOD=0 KUO=0 KVSAT=0 TKUO=0 LKUO=0 WKUO=0 PKUO=0 LLODKUO=0 WLODKUO=0 KVTHO=0 LKVTHO=0 WKVTHO=0 PKVTHO=0 LLODVTH=0 WLODVTH=0 STETAO=0 LODETAO=1 SCREF=1e-06 WEB=0 WEC=0 KVTHOWEO=0 KVTHOWEL=0 KVTHOWEW=0 KVTHOWELW=0 KUOWEO=0 KUOWEL=0 KUOWEW=0 KUOWELW=0 TRJ=21 SWJUNEXP=0 IMAX=0.0020128 FREV=1000 CJORBOT=0.00085856 CJORSTI=2.4557e-11 CJORGAT=1.3846e-11 VBIRBOT=0.74373 VBIRSTI=1.597 VBIRGAT=0.6629 PBOT=0.27424 PSTI=0.16571 PGAT=0.1451 CJORBOTD=0.001 CJORSTID=1e-09 CJORGATD=1e-09 VBIRBOTD=1 VBIRSTID=1 VBIRGATD=1 PBOTD=0.5 PSTID=0.5 PGATD=0.5 PHIGBOT=1.1984 PHIGSTI=1.006 PHIGGAT=0.3 IDSATRBOT=5.397e-08 IDSATRSTI=4.0612e-15 IDSATRGAT=0 CSRHBOT=100 CSRHSTI=0.0001 CSRHGAT=0.0001 XJUNSTI=1.61e-08 XJUNGAT=6.134e-07 PHIGBOTD=1.16 PHIGSTID=1.16 PHIGGATD=1.16 IDSATRBOTD=1e-12 IDSATRSTID=1e-18 IDSATRGATD=1e-18 CSRHBOTD=100 CSRHSTID=0.0001 CSRHGATD=0.0001 XJUNSTID=1e-07 XJUNGATD=1e-07 CTATBOT=100 CTATSTI=0.0001 CTATGAT=0.0001 MEFFTATBOT=0.25 MEFFTATSTI=0.25 MEFFTATGAT=0.25 CTATBOTD=100 CTATSTID=0.0001 CTATGATD=0.0001 MEFFTATBOTD=0.25 MEFFTATSTID=0.25 MEFFTATGATD=0.25 CBBTBOT=1e-12 CBBTSTI=1e-21 CBBTGAT=1e-18 FBBTRBOT=1000000000 FBBTRSTI=1000000000 FBBTRGAT=1000000000 STFBBTBOT=-0.001 STFBBTSTI=-0.001 STFBBTGAT=-0.001 CBBTBOTD=1e-12 CBBTSTID=1e-18 CBBTGATD=1e-18 FBBTRBOTD=1000000000 FBBTRSTID=1000000000 FBBTRGATD=1000000000 STFBBTBOTD=-0.001 STFBBTSTID=-0.001 STFBBTGATD=-0.001 VBRBOT=10 VBRSTI=10 VBRGAT=10 PBRBOT=4 PBRSTI=4 PBRGAT=4 VBRBOTD=10 VBRSTID=10 VBRGATD=10 PBRBOTD=4 PBRSTID=4 PBRGATD=4 VJUNREF=2.5 FJUNQ=0.03 VJUNREFD=2.5 FJUNQD=0.03 RINT=3.0856e-12 RVPOLY=0 DLSIL=0 RSH=0 RSHD=0 CFRW=6e-17 RSHG=20 RGO=35 RBULKO=234.5984 RWELLO=234.5984 RJUNSO=131.9616 RJUNDO=131.9616 SWSOA=0 VGS_MAX=3 VGD_MAX=3 VGB_MAX=3 VDS_MAX=3 VDB_MAX=1.6 VSB_MAX=1.6
model hvn_w17264n_l2000n_ng2 PSP103VA TYPE=1 TR=27 DTA=0 SWGEO=1 SWIGATE=1 SWIMPACT=1 SWGIDL=0 SWJUNCAP=3 SWJUNASYM=0 SWNUD=0 SWEDGE=0 SWDELVTAC=0 SWIGN=1 QMC=1 LVARO=3.499e-08 LVARL=-0.09125 LVARW=0 LAP=6.3866e-08 WVARO=0 WVARL=0 WVARW=0 WOT=3e-08 DLQ=5.2202e-08 DWQ=3e-08 VFBO=-0.89839 VFBL=0.15096 VFBW=0.0017033 VFBLW=0.019398 STVFBO=0.0008739 STVFBL=0.00014864 STVFBW=-4.6174e-05 STVFBLW=-2.445e-06 ST2VFBO=0 TOXO=7.4256e-09 EPSROXO=3.9 NSUBO=1.8552e+23 NSUBW=-0.0050198 WSEG=1.098e-10 NPCK=3.178e+23 NPCKW=-2.7604 WSEGP=1e-08 LPCK=1e-08 LPCKW=0 FOL1=0.21033 FOL2=0.0026472 FACNEFFACO=1 FACNEFFACL=0 FACNEFFACW=0 FACNEFFACLW=0 GFACNUDO=1 GFACNUDL=0 GFACNUDLEXP=1 GFACNUDW=0 GFACNUDLW=0 VSBNUDO=0 DVSBNUDO=1 VNSUBO=0 NSLPO=0.05 DNSUBO=0.025686 DPHIBO=-0.0607576464 DPHIBL=-0.00546403785 DPHIBLEXP=2.3956 DPHIBW=0.014614 DPHIBLW=-0.017476272 DELVTACO=0 DELVTACL=0 DELVTACLEXP=1 DELVTACW=0 DELVTACLW=0 NPO=3.897e+26 NPL=-0.1215 TOXOVO=7.4256e-09 TOXOVDO=2e-09 LOV=6.3866e-08 LOVD=0 NOVO=5.5814e+24 NOVDO=5e+25 CTO=-0.061658 CTL=0.025 CTLEXP=1.6063 CTW=-0.044911 CTLW=-0.0077386 CTGO=0 CTBO=0 STCTO=1 CFL=0.0048288 CFLEXP=1.3328 CFW=0.037319 CFBO=0.26069 CFDO=0 PSCEL=0 PSCELEXP=2 PSCEW=0 PSCEBO=0 PSCEDO=0 UO=0.046687 FBET1=-0.35712 FBET1W=-0.14995 LP1=4.5615e-08 LP1W=0.4189 FBET2=-1.0245 LP2=9.42e-09 BETW1=0.6567 BETW2=-0.083639 WBET=1.0063e-10 STBETO=1.6942 STBETL=-0.0065587 STBETW=-0.060053 STBETLW=0.00036994 MUEO=0.91692524 MUEW=-0.018226 STMUEO=0.34067 THEMUO=2.5509 STTHEMUO=0.63756 CSO=2.0494 CSL=-0.97261 CSLEXP=0 CSW=0.044205 CSLW=-1.0021 STCSO=2.5545 THECSO=2 STTHECSO=0 XCORO=0.04872 XCORL=-0.27137 XCORW=-0.1948 XCORLW=0 STXCORO=1.1327 FETAO=1.0706 RSW1=321.598966 RSW2=-0.07 STRSO=-0.058157 RSBO=-0.0025425 RSGO=0.10986 THESATO=0.1 THESATL=0.446499 THESATLEXP=1.0973 THESATW=0.082797 THESATLW=-0.032897685 STTHESATO=0.48396 STTHESATL=0.50226 STTHESATW=0.049985 STTHESATLW=-0.059487 THESATBO=0.06 THESATGO=0.050814 AXO=8.7694 AXL=2.3029 ALPL=0.0019702 ALPLEXP=1.4003 ALPW=1.1052 ALP1L1=0.007475 ALP1LEXP=0.80983 ALP1L2=0.719 ALP1W=0.56703 ALP2L1=5.413e-07 ALP2LEXP=0.2541 ALP2L2=0 ALP2W=-10 VPO=0.06567 A1O=4.7288 A1L=0.052459 A1W=0.024056 A2O=22.013 STA2O=0.018532 A3O=1.2047 A3L=-0.10308 A3W=0.0069117 A4O=0.12894 A4L=-0.05413 A4W=-0.06197 GCOO=0 IGINVLW=0 IGOVW=0 IGOVDW=0 STIGO=2 GC2O=0.375 GC3O=0.063 CHIBO=3.1 AGIDLW=70 AGIDLDW=0 BGIDLO=13 BGIDLDO=41 STBGIDLO=-0.001067 STBGIDLDO=0 CGIDLO=0 CGIDLDO=0 CGBOVL=2.522e-16 CFRDW=0 FNTO=1 FNTEXCL=0 NFALW=1.42e+25 NFBLW=574300000 NFCLW=-3.015e-08 EFO=1 LINTNOI=-3.158e-08 ALPNOI=2.708 WEDGE=1e-08 WEDGEW=0 VFBEDGEO=-1 STVFBEDGEO=0.0005 STVFBEDGEL=0 STVFBEDGEW=0 STVFBEDGELW=0 DPHIBEDGEO=0 DPHIBEDGEL=0 DPHIBEDGELEXP=1 DPHIBEDGEW=0 DPHIBEDGELW=0 NSUBEDGEO=5e+23 NSUBEDGEL=0 NSUBEDGELEXP=1 NSUBEDGEW=0 NSUBEDGELW=0 CTEDGEO=0 CTEDGEL=0 CTEDGELEXP=1 FBETEDGE=0 LPEDGE=1e-08 BETEDGEW=0 STBETEDGEO=1 STBETEDGEL=0 STBETEDGEW=0 STBETEDGELW=0 PSCEEDGEL=0 PSCEEDGELEXP=2 PSCEEDGEW=0 PSCEBEDGEO=0 PSCEDEDGEO=0 CFEDGEL=0 CFEDGELEXP=2 CFEDGEW=0 CFDEDGEO=0 CFBEDGEO=0 FNTEDGEO=1 NFAEDGELW=8e+22 NFBEDGELW=30000000 NFCEDGELW=0 EFEDGEO=1 SAREF=1e-06 SBREF=1e-06 WLOD=0 KUO=0 KVSAT=0 TKUO=0 LKUO=0 WKUO=0 PKUO=0 LLODKUO=0 WLODKUO=0 KVTHO=0 LKVTHO=0 WKVTHO=0 PKVTHO=0 LLODVTH=0 WLODVTH=0 STETAO=0 LODETAO=1 SCREF=1e-06 WEB=0 WEC=0 KVTHOWEO=0 KVTHOWEL=0 KVTHOWEW=0 KVTHOWELW=0 KUOWEO=0 KUOWEL=0 KUOWEW=0 KUOWELW=0 TRJ=21 SWJUNEXP=0 IMAX=0.0020128 FREV=1000 CJORBOT=0.00085856 CJORSTI=2.4557e-11 CJORGAT=1.3846e-11 VBIRBOT=0.74373 VBIRSTI=1.597 VBIRGAT=0.6629 PBOT=0.27424 PSTI=0.16571 PGAT=0.1451 CJORBOTD=0.001 CJORSTID=1e-09 CJORGATD=1e-09 VBIRBOTD=1 VBIRSTID=1 VBIRGATD=1 PBOTD=0.5 PSTID=0.5 PGATD=0.5 PHIGBOT=1.1984 PHIGSTI=1.006 PHIGGAT=0.3 IDSATRBOT=5.397e-08 IDSATRSTI=4.0612e-15 IDSATRGAT=0 CSRHBOT=100 CSRHSTI=0.0001 CSRHGAT=0.0001 XJUNSTI=1.61e-08 XJUNGAT=6.134e-07 PHIGBOTD=1.16 PHIGSTID=1.16 PHIGGATD=1.16 IDSATRBOTD=1e-12 IDSATRSTID=1e-18 IDSATRGATD=1e-18 CSRHBOTD=100 CSRHSTID=0.0001 CSRHGATD=0.0001 XJUNSTID=1e-07 XJUNGATD=1e-07 CTATBOT=100 CTATSTI=0.0001 CTATGAT=0.0001 MEFFTATBOT=0.25 MEFFTATSTI=0.25 MEFFTATGAT=0.25 CTATBOTD=100 CTATSTID=0.0001 CTATGATD=0.0001 MEFFTATBOTD=0.25 MEFFTATSTID=0.25 MEFFTATGATD=0.25 CBBTBOT=1e-12 CBBTSTI=1e-21 CBBTGAT=1e-18 FBBTRBOT=1000000000 FBBTRSTI=1000000000 FBBTRGAT=1000000000 STFBBTBOT=-0.001 STFBBTSTI=-0.001 STFBBTGAT=-0.001 CBBTBOTD=1e-12 CBBTSTID=1e-18 CBBTGATD=1e-18 FBBTRBOTD=1000000000 FBBTRSTID=1000000000 FBBTRGATD=1000000000 STFBBTBOTD=-0.001 STFBBTSTID=-0.001 STFBBTGATD=-0.001 VBRBOT=10 VBRSTI=10 VBRGAT=10 PBRBOT=4 PBRSTI=4 PBRGAT=4 VBRBOTD=10 VBRSTID=10 VBRGATD=10 PBRBOTD=4 PBRSTID=4 PBRGATD=4 VJUNREF=2.5 FJUNQ=0.03 VJUNREFD=2.5 FJUNQD=0.03 RINT=3.0856e-12 RVPOLY=0 DLSIL=0 RSH=0 RSHD=0 CFRW=6e-17 RSHG=20 RGO=35 RBULKO=231.7021235 RWELLO=231.7021235 RJUNSO=579.2553086 RJUNDO=579.2553086 SWSOA=0 VGS_MAX=3 VGD_MAX=3 VGB_MAX=3 VDS_MAX=3 VDB_MAX=1.6 VSB_MAX=1.6
model hvn_w2000n_l1000n_ng1 PSP103VA TYPE=1 TR=27 DTA=0 SWGEO=1 SWIGATE=1 SWIMPACT=1 SWGIDL=0 SWJUNCAP=3 SWJUNASYM=0 SWNUD=0 SWEDGE=0 SWDELVTAC=0 SWIGN=1 QMC=1 LVARO=3.499e-08 LVARL=-0.09125 LVARW=0 LAP=6.3866e-08 WVARO=0 WVARL=0 WVARW=0 WOT=3e-08 DLQ=5.2202e-08 DWQ=3e-08 VFBO=-0.89839 VFBL=0.15096 VFBW=0.0017033 VFBLW=0.019398 STVFBO=0.0008739 STVFBL=0.00014864 STVFBW=-4.6174e-05 STVFBLW=-2.445e-06 ST2VFBO=0 TOXO=7.4256e-09 EPSROXO=3.9 NSUBO=1.8552e+23 NSUBW=-0.0050198 WSEG=1.098e-10 NPCK=3.178e+23 NPCKW=-2.7604 WSEGP=1e-08 LPCK=1e-08 LPCKW=0 FOL1=0.21033 FOL2=0.0026472 FACNEFFACO=1 FACNEFFACL=0 FACNEFFACW=0 FACNEFFACLW=0 GFACNUDO=1 GFACNUDL=0 GFACNUDLEXP=1 GFACNUDW=0 GFACNUDLW=0 VSBNUDO=0 DVSBNUDO=1 VNSUBO=0 NSLPO=0.05 DNSUBO=0.025686 DPHIBO=-0.0607576464 DPHIBL=-0.00546403785 DPHIBLEXP=2.3956 DPHIBW=0.014614 DPHIBLW=-0.017476272 DELVTACO=0 DELVTACL=0 DELVTACLEXP=1 DELVTACW=0 DELVTACLW=0 NPO=3.897e+26 NPL=-0.1215 TOXOVO=7.4256e-09 TOXOVDO=2e-09 LOV=6.3866e-08 LOVD=0 NOVO=5.5814e+24 NOVDO=5e+25 CTO=-0.061658 CTL=0.025 CTLEXP=1.6063 CTW=-0.044911 CTLW=-0.0077386 CTGO=0 CTBO=0 STCTO=1 CFL=0.0048288 CFLEXP=1.3328 CFW=0.037319 CFBO=0.26069 CFDO=0 PSCEL=0 PSCELEXP=2 PSCEW=0 PSCEBO=0 PSCEDO=0 UO=0.046687 FBET1=-0.35712 FBET1W=-0.14995 LP1=4.5615e-08 LP1W=0.4189 FBET2=-1.0245 LP2=9.42e-09 BETW1=0.6567 BETW2=-0.083639 WBET=1.0063e-10 STBETO=1.6942 STBETL=-0.0065587 STBETW=-0.060053 STBETLW=0.00036994 MUEO=0.91692524 MUEW=-0.018226 STMUEO=0.34067 THEMUO=2.5509 STTHEMUO=0.63756 CSO=2.0494 CSL=-0.97261 CSLEXP=0 CSW=0.044205 CSLW=-1.0021 STCSO=2.5545 THECSO=2 STTHECSO=0 XCORO=0.04872 XCORL=-0.27137 XCORW=-0.1948 XCORLW=0 STXCORO=1.1327 FETAO=1.0706 RSW1=321.598966 RSW2=-0.07 STRSO=-0.058157 RSBO=-0.0025425 RSGO=0.10986 THESATO=0.1 THESATL=0.446499 THESATLEXP=1.0973 THESATW=0.082797 THESATLW=-0.032897685 STTHESATO=0.48396 STTHESATL=0.50226 STTHESATW=0.049985 STTHESATLW=-0.059487 THESATBO=0.06 THESATGO=0.050814 AXO=8.7694 AXL=2.3029 ALPL=0.0019702 ALPLEXP=1.4003 ALPW=1.1052 ALP1L1=0.007475 ALP1LEXP=0.80983 ALP1L2=0.719 ALP1W=0.56703 ALP2L1=5.413e-07 ALP2LEXP=0.2541 ALP2L2=0 ALP2W=-10 VPO=0.06567 A1O=4.7288 A1L=0.052459 A1W=0.024056 A2O=22.013 STA2O=0.018532 A3O=1.2047 A3L=-0.10308 A3W=0.0069117 A4O=0.12894 A4L=-0.05413 A4W=-0.06197 GCOO=0 IGINVLW=0 IGOVW=0 IGOVDW=0 STIGO=2 GC2O=0.375 GC3O=0.063 CHIBO=3.1 AGIDLW=70 AGIDLDW=0 BGIDLO=13 BGIDLDO=41 STBGIDLO=-0.001067 STBGIDLDO=0 CGIDLO=0 CGIDLDO=0 CGBOVL=2.522e-16 CFRDW=0 FNTO=1 FNTEXCL=0 NFALW=1.42e+25 NFBLW=574300000 NFCLW=-3.015e-08 EFO=1 LINTNOI=-3.158e-08 ALPNOI=2.708 WEDGE=1e-08 WEDGEW=0 VFBEDGEO=-1 STVFBEDGEO=0.0005 STVFBEDGEL=0 STVFBEDGEW=0 STVFBEDGELW=0 DPHIBEDGEO=0 DPHIBEDGEL=0 DPHIBEDGELEXP=1 DPHIBEDGEW=0 DPHIBEDGELW=0 NSUBEDGEO=5e+23 NSUBEDGEL=0 NSUBEDGELEXP=1 NSUBEDGEW=0 NSUBEDGELW=0 CTEDGEO=0 CTEDGEL=0 CTEDGELEXP=1 FBETEDGE=0 LPEDGE=1e-08 BETEDGEW=0 STBETEDGEO=1 STBETEDGEL=0 STBETEDGEW=0 STBETEDGELW=0 PSCEEDGEL=0 PSCEEDGELEXP=2 PSCEEDGEW=0 PSCEBEDGEO=0 PSCEDEDGEO=0 CFEDGEL=0 CFEDGELEXP=2 CFEDGEW=0 CFDEDGEO=0 CFBEDGEO=0 FNTEDGEO=1 NFAEDGELW=8e+22 NFBEDGELW=30000000 NFCEDGELW=0 EFEDGEO=1 SAREF=1e-06 SBREF=1e-06 WLOD=0 KUO=0 KVSAT=0 TKUO=0 LKUO=0 WKUO=0 PKUO=0 LLODKUO=0 WLODKUO=0 KVTHO=0 LKVTHO=0 WKVTHO=0 PKVTHO=0 LLODVTH=0 WLODVTH=0 STETAO=0 LODETAO=1 SCREF=1e-06 WEB=0 WEC=0 KVTHOWEO=0 KVTHOWEL=0 KVTHOWEW=0 KVTHOWELW=0 KUOWEO=0 KUOWEL=0 KUOWEW=0 KUOWELW=0 TRJ=21 SWJUNEXP=0 IMAX=0.0020128 FREV=1000 CJORBOT=0.00085856 CJORSTI=2.4557e-11 CJORGAT=1.3846e-11 VBIRBOT=0.74373 VBIRSTI=1.597 VBIRGAT=0.6629 PBOT=0.27424 PSTI=0.16571 PGAT=0.1451 CJORBOTD=0.001 CJORSTID=1e-09 CJORGATD=1e-09 VBIRBOTD=1 VBIRSTID=1 VBIRGATD=1 PBOTD=0.5 PSTID=0.5 PGATD=0.5 PHIGBOT=1.1984 PHIGSTI=1.006 PHIGGAT=0.3 IDSATRBOT=5.397e-08 IDSATRSTI=4.0612e-15 IDSATRGAT=0 CSRHBOT=100 CSRHSTI=0.0001 CSRHGAT=0.0001 XJUNSTI=1.61e-08 XJUNGAT=6.134e-07 PHIGBOTD=1.16 PHIGSTID=1.16 PHIGGATD=1.16 IDSATRBOTD=1e-12 IDSATRSTID=1e-18 IDSATRGATD=1e-18 CSRHBOTD=100 CSRHSTID=0.0001 CSRHGATD=0.0001 XJUNSTID=1e-07 XJUNGATD=1e-07 CTATBOT=100 CTATSTI=0.0001 CTATGAT=0.0001 MEFFTATBOT=0.25 MEFFTATSTI=0.25 MEFFTATGAT=0.25 CTATBOTD=100 CTATSTID=0.0001 CTATGATD=0.0001 MEFFTATBOTD=0.25 MEFFTATSTID=0.25 MEFFTATGATD=0.25 CBBTBOT=1e-12 CBBTSTI=1e-21 CBBTGAT=1e-18 FBBTRBOT=1000000000 FBBTRSTI=1000000000 FBBTRGAT=1000000000 STFBBTBOT=-0.001 STFBBTSTI=-0.001 STFBBTGAT=-0.001 CBBTBOTD=1e-12 CBBTSTID=1e-18 CBBTGATD=1e-18 FBBTRBOTD=1000000000 FBBTRSTID=1000000000 FBBTRGATD=1000000000 STFBBTBOTD=-0.001 STFBBTSTID=-0.001 STFBBTGATD=-0.001 VBRBOT=10 VBRSTI=10 VBRGAT=10 PBRBOT=4 PBRSTI=4 PBRGAT=4 VBRBOTD=10 VBRSTID=10 VBRGATD=10 PBRBOTD=4 PBRSTID=4 PBRGATD=4 VJUNREF=2.5 FJUNQ=0.03 VJUNREFD=2.5 FJUNQD=0.03 RINT=3.0856e-12 RVPOLY=0 DLSIL=0 RSH=0 RSHD=0 CFRW=1.2e-16 RSHG=20 RGO=35 RBULKO=1000 RWELLO=1000 RJUNSO=2500 RJUNDO=2500 SWSOA=0 VGS_MAX=3 VGD_MAX=3 VGB_MAX=3 VDS_MAX=3 VDB_MAX=1.6 VSB_MAX=1.6
model hvn_w2000n_l450n_ng1 PSP103VA TYPE=1 TR=27 DTA=0 SWGEO=1 SWIGATE=1 SWIMPACT=1 SWGIDL=0 SWJUNCAP=3 SWJUNASYM=0 SWNUD=0 SWEDGE=0 SWDELVTAC=0 SWIGN=1 QMC=1 LVARO=3.499e-08 LVARL=-0.09125 LVARW=0 LAP=6.3866e-08 WVARO=0 WVARL=0 WVARW=0 WOT=3e-08 DLQ=5.2202e-08 DWQ=3e-08 VFBO=-0.89839 VFBL=0.15096 VFBW=0.0017033 VFBLW=0.019398 STVFBO=0.0008739 STVFBL=0.00014864 STVFBW=-4.6174e-05 STVFBLW=-2.445e-06 ST2VFBO=0 TOXO=7.4256e-09 EPSROXO=3.9 NSUBO=1.8552e+23 NSUBW=-0.0050198 WSEG=1.098e-10 NPCK=3.178e+23 NPCKW=-2.7604 WSEGP=1e-08 LPCK=1e-08 LPCKW=0 FOL1=0.21033 FOL2=0.0026472 FACNEFFACO=1 FACNEFFACL=0 FACNEFFACW=0 FACNEFFACLW=0 GFACNUDO=1 GFACNUDL=0 GFACNUDLEXP=1 GFACNUDW=0 GFACNUDLW=0 VSBNUDO=0 DVSBNUDO=1 VNSUBO=0 NSLPO=0.05 DNSUBO=0.025686 DPHIBO=-0.0607576464 DPHIBL=-0.00546403785 DPHIBLEXP=2.3956 DPHIBW=0.014614 DPHIBLW=-0.017476272 DELVTACO=0 DELVTACL=0 DELVTACLEXP=1 DELVTACW=0 DELVTACLW=0 NPO=3.897e+26 NPL=-0.1215 TOXOVO=7.4256e-09 TOXOVDO=2e-09 LOV=6.3866e-08 LOVD=0 NOVO=5.5814e+24 NOVDO=5e+25 CTO=-0.061658 CTL=0.025 CTLEXP=1.6063 CTW=-0.044911 CTLW=-0.0077386 CTGO=0 CTBO=0 STCTO=1 CFL=0.0048288 CFLEXP=1.3328 CFW=0.037319 CFBO=0.26069 CFDO=0 PSCEL=0 PSCELEXP=2 PSCEW=0 PSCEBO=0 PSCEDO=0 UO=0.046687 FBET1=-0.35712 FBET1W=-0.14995 LP1=4.5615e-08 LP1W=0.4189 FBET2=-1.0245 LP2=9.42e-09 BETW1=0.6567 BETW2=-0.083639 WBET=1.0063e-10 STBETO=1.6942 STBETL=-0.0065587 STBETW=-0.060053 STBETLW=0.00036994 MUEO=0.91692524 MUEW=-0.018226 STMUEO=0.34067 THEMUO=2.5509 STTHEMUO=0.63756 CSO=2.0494 CSL=-0.97261 CSLEXP=0 CSW=0.044205 CSLW=-1.0021 STCSO=2.5545 THECSO=2 STTHECSO=0 XCORO=0.04872 XCORL=-0.27137 XCORW=-0.1948 XCORLW=0 STXCORO=1.1327 FETAO=1.0706 RSW1=321.598966 RSW2=-0.07 STRSO=-0.058157 RSBO=-0.0025425 RSGO=0.10986 THESATO=0.1 THESATL=0.446499 THESATLEXP=1.0973 THESATW=0.082797 THESATLW=-0.032897685 STTHESATO=0.48396 STTHESATL=0.50226 STTHESATW=0.049985 STTHESATLW=-0.059487 THESATBO=0.06 THESATGO=0.050814 AXO=8.7694 AXL=2.3029 ALPL=0.0019702 ALPLEXP=1.4003 ALPW=1.1052 ALP1L1=0.007475 ALP1LEXP=0.80983 ALP1L2=0.719 ALP1W=0.56703 ALP2L1=5.413e-07 ALP2LEXP=0.2541 ALP2L2=0 ALP2W=-10 VPO=0.06567 A1O=4.7288 A1L=0.052459 A1W=0.024056 A2O=22.013 STA2O=0.018532 A3O=1.2047 A3L=-0.10308 A3W=0.0069117 A4O=0.12894 A4L=-0.05413 A4W=-0.06197 GCOO=0 IGINVLW=0 IGOVW=0 IGOVDW=0 STIGO=2 GC2O=0.375 GC3O=0.063 CHIBO=3.1 AGIDLW=70 AGIDLDW=0 BGIDLO=13 BGIDLDO=41 STBGIDLO=-0.001067 STBGIDLDO=0 CGIDLO=0 CGIDLDO=0 CGBOVL=2.522e-16 CFRDW=0 FNTO=1 FNTEXCL=0 NFALW=1.42e+25 NFBLW=574300000 NFCLW=-3.015e-08 EFO=1 LINTNOI=-3.158e-08 ALPNOI=2.708 WEDGE=1e-08 WEDGEW=0 VFBEDGEO=-1 STVFBEDGEO=0.0005 STVFBEDGEL=0 STVFBEDGEW=0 STVFBEDGELW=0 DPHIBEDGEO=0 DPHIBEDGEL=0 DPHIBEDGELEXP=1 DPHIBEDGEW=0 DPHIBEDGELW=0 NSUBEDGEO=5e+23 NSUBEDGEL=0 NSUBEDGELEXP=1 NSUBEDGEW=0 NSUBEDGELW=0 CTEDGEO=0 CTEDGEL=0 CTEDGELEXP=1 FBETEDGE=0 LPEDGE=1e-08 BETEDGEW=0 STBETEDGEO=1 STBETEDGEL=0 STBETEDGEW=0 STBETEDGELW=0 PSCEEDGEL=0 PSCEEDGELEXP=2 PSCEEDGEW=0 PSCEBEDGEO=0 PSCEDEDGEO=0 CFEDGEL=0 CFEDGELEXP=2 CFEDGEW=0 CFDEDGEO=0 CFBEDGEO=0 FNTEDGEO=1 NFAEDGELW=8e+22 NFBEDGELW=30000000 NFCEDGELW=0 EFEDGEO=1 SAREF=1e-06 SBREF=1e-06 WLOD=0 KUO=0 KVSAT=0 TKUO=0 LKUO=0 WKUO=0 PKUO=0 LLODKUO=0 WLODKUO=0 KVTHO=0 LKVTHO=0 WKVTHO=0 PKVTHO=0 LLODVTH=0 WLODVTH=0 STETAO=0 LODETAO=1 SCREF=1e-06 WEB=0 WEC=0 KVTHOWEO=0 KVTHOWEL=0 KVTHOWEW=0 KVTHOWELW=0 KUOWEO=0 KUOWEL=0 KUOWEW=0 KUOWELW=0 TRJ=21 SWJUNEXP=0 IMAX=0.0020128 FREV=1000 CJORBOT=0.00085856 CJORSTI=2.4557e-11 CJORGAT=1.3846e-11 VBIRBOT=0.74373 VBIRSTI=1.597 VBIRGAT=0.6629 PBOT=0.27424 PSTI=0.16571 PGAT=0.1451 CJORBOTD=0.001 CJORSTID=1e-09 CJORGATD=1e-09 VBIRBOTD=1 VBIRSTID=1 VBIRGATD=1 PBOTD=0.5 PSTID=0.5 PGATD=0.5 PHIGBOT=1.1984 PHIGSTI=1.006 PHIGGAT=0.3 IDSATRBOT=5.397e-08 IDSATRSTI=4.0612e-15 IDSATRGAT=0 CSRHBOT=100 CSRHSTI=0.0001 CSRHGAT=0.0001 XJUNSTI=1.61e-08 XJUNGAT=6.134e-07 PHIGBOTD=1.16 PHIGSTID=1.16 PHIGGATD=1.16 IDSATRBOTD=1e-12 IDSATRSTID=1e-18 IDSATRGATD=1e-18 CSRHBOTD=100 CSRHSTID=0.0001 CSRHGATD=0.0001 XJUNSTID=1e-07 XJUNGATD=1e-07 CTATBOT=100 CTATSTI=0.0001 CTATGAT=0.0001 MEFFTATBOT=0.25 MEFFTATSTI=0.25 MEFFTATGAT=0.25 CTATBOTD=100 CTATSTID=0.0001 CTATGATD=0.0001 MEFFTATBOTD=0.25 MEFFTATSTID=0.25 MEFFTATGATD=0.25 CBBTBOT=1e-12 CBBTSTI=1e-21 CBBTGAT=1e-18 FBBTRBOT=1000000000 FBBTRSTI=1000000000 FBBTRGAT=1000000000 STFBBTBOT=-0.001 STFBBTSTI=-0.001 STFBBTGAT=-0.001 CBBTBOTD=1e-12 CBBTSTID=1e-18 CBBTGATD=1e-18 FBBTRBOTD=1000000000 FBBTRSTID=1000000000 FBBTRGATD=1000000000 STFBBTBOTD=-0.001 STFBBTSTID=-0.001 STFBBTGATD=-0.001 VBRBOT=10 VBRSTI=10 VBRGAT=10 PBRBOT=4 PBRSTI=4 PBRGAT=4 VBRBOTD=10 VBRSTID=10 VBRGATD=10 PBRBOTD=4 PBRSTID=4 PBRGATD=4 VJUNREF=2.5 FJUNQ=0.03 VJUNREFD=2.5 FJUNQD=0.03 RINT=3.0856e-12 RVPOLY=0 DLSIL=0 RSH=0 RSHD=0 CFRW=1.2e-16 RSHG=20 RGO=35 RBULKO=1000 RWELLO=1000 RJUNSO=1125 RJUNDO=1125 SWSOA=0 VGS_MAX=3 VGD_MAX=3 VGB_MAX=3 VDS_MAX=3 VDB_MAX=1.6 VSB_MAX=1.6
model hvn_w3446n_l450n_ng1 PSP103VA TYPE=1 TR=27 DTA=0 SWGEO=1 SWIGATE=1 SWIMPACT=1 SWGIDL=0 SWJUNCAP=3 SWJUNASYM=0 SWNUD=0 SWEDGE=0 SWDELVTAC=0 SWIGN=1 QMC=1 LVARO=3.499e-08 LVARL=-0.09125 LVARW=0 LAP=6.3866e-08 WVARO=0 WVARL=0 WVARW=0 WOT=3e-08 DLQ=5.2202e-08 DWQ=3e-08 VFBO=-0.89839 VFBL=0.15096 VFBW=0.0017033 VFBLW=0.019398 STVFBO=0.0008739 STVFBL=0.00014864 STVFBW=-4.6174e-05 STVFBLW=-2.445e-06 ST2VFBO=0 TOXO=7.4256e-09 EPSROXO=3.9 NSUBO=1.8552e+23 NSUBW=-0.0050198 WSEG=1.098e-10 NPCK=3.178e+23 NPCKW=-2.7604 WSEGP=1e-08 LPCK=1e-08 LPCKW=0 FOL1=0.21033 FOL2=0.0026472 FACNEFFACO=1 FACNEFFACL=0 FACNEFFACW=0 FACNEFFACLW=0 GFACNUDO=1 GFACNUDL=0 GFACNUDLEXP=1 GFACNUDW=0 GFACNUDLW=0 VSBNUDO=0 DVSBNUDO=1 VNSUBO=0 NSLPO=0.05 DNSUBO=0.025686 DPHIBO=-0.0607576464 DPHIBL=-0.00546403785 DPHIBLEXP=2.3956 DPHIBW=0.014614 DPHIBLW=-0.017476272 DELVTACO=0 DELVTACL=0 DELVTACLEXP=1 DELVTACW=0 DELVTACLW=0 NPO=3.897e+26 NPL=-0.1215 TOXOVO=7.4256e-09 TOXOVDO=2e-09 LOV=6.3866e-08 LOVD=0 NOVO=5.5814e+24 NOVDO=5e+25 CTO=-0.061658 CTL=0.025 CTLEXP=1.6063 CTW=-0.044911 CTLW=-0.0077386 CTGO=0 CTBO=0 STCTO=1 CFL=0.0048288 CFLEXP=1.3328 CFW=0.037319 CFBO=0.26069 CFDO=0 PSCEL=0 PSCELEXP=2 PSCEW=0 PSCEBO=0 PSCEDO=0 UO=0.046687 FBET1=-0.35712 FBET1W=-0.14995 LP1=4.5615e-08 LP1W=0.4189 FBET2=-1.0245 LP2=9.42e-09 BETW1=0.6567 BETW2=-0.083639 WBET=1.0063e-10 STBETO=1.6942 STBETL=-0.0065587 STBETW=-0.060053 STBETLW=0.00036994 MUEO=0.91692524 MUEW=-0.018226 STMUEO=0.34067 THEMUO=2.5509 STTHEMUO=0.63756 CSO=2.0494 CSL=-0.97261 CSLEXP=0 CSW=0.044205 CSLW=-1.0021 STCSO=2.5545 THECSO=2 STTHECSO=0 XCORO=0.04872 XCORL=-0.27137 XCORW=-0.1948 XCORLW=0 STXCORO=1.1327 FETAO=1.0706 RSW1=321.598966 RSW2=-0.07 STRSO=-0.058157 RSBO=-0.0025425 RSGO=0.10986 THESATO=0.1 THESATL=0.446499 THESATLEXP=1.0973 THESATW=0.082797 THESATLW=-0.032897685 STTHESATO=0.48396 STTHESATL=0.50226 STTHESATW=0.049985 STTHESATLW=-0.059487 THESATBO=0.06 THESATGO=0.050814 AXO=8.7694 AXL=2.3029 ALPL=0.0019702 ALPLEXP=1.4003 ALPW=1.1052 ALP1L1=0.007475 ALP1LEXP=0.80983 ALP1L2=0.719 ALP1W=0.56703 ALP2L1=5.413e-07 ALP2LEXP=0.2541 ALP2L2=0 ALP2W=-10 VPO=0.06567 A1O=4.7288 A1L=0.052459 A1W=0.024056 A2O=22.013 STA2O=0.018532 A3O=1.2047 A3L=-0.10308 A3W=0.0069117 A4O=0.12894 A4L=-0.05413 A4W=-0.06197 GCOO=0 IGINVLW=0 IGOVW=0 IGOVDW=0 STIGO=2 GC2O=0.375 GC3O=0.063 CHIBO=3.1 AGIDLW=70 AGIDLDW=0 BGIDLO=13 BGIDLDO=41 STBGIDLO=-0.001067 STBGIDLDO=0 CGIDLO=0 CGIDLDO=0 CGBOVL=2.522e-16 CFRDW=0 FNTO=1 FNTEXCL=0 NFALW=1.42e+25 NFBLW=574300000 NFCLW=-3.015e-08 EFO=1 LINTNOI=-3.158e-08 ALPNOI=2.708 WEDGE=1e-08 WEDGEW=0 VFBEDGEO=-1 STVFBEDGEO=0.0005 STVFBEDGEL=0 STVFBEDGEW=0 STVFBEDGELW=0 DPHIBEDGEO=0 DPHIBEDGEL=0 DPHIBEDGELEXP=1 DPHIBEDGEW=0 DPHIBEDGELW=0 NSUBEDGEO=5e+23 NSUBEDGEL=0 NSUBEDGELEXP=1 NSUBEDGEW=0 NSUBEDGELW=0 CTEDGEO=0 CTEDGEL=0 CTEDGELEXP=1 FBETEDGE=0 LPEDGE=1e-08 BETEDGEW=0 STBETEDGEO=1 STBETEDGEL=0 STBETEDGEW=0 STBETEDGELW=0 PSCEEDGEL=0 PSCEEDGELEXP=2 PSCEEDGEW=0 PSCEBEDGEO=0 PSCEDEDGEO=0 CFEDGEL=0 CFEDGELEXP=2 CFEDGEW=0 CFDEDGEO=0 CFBEDGEO=0 FNTEDGEO=1 NFAEDGELW=8e+22 NFBEDGELW=30000000 NFCEDGELW=0 EFEDGEO=1 SAREF=1e-06 SBREF=1e-06 WLOD=0 KUO=0 KVSAT=0 TKUO=0 LKUO=0 WKUO=0 PKUO=0 LLODKUO=0 WLODKUO=0 KVTHO=0 LKVTHO=0 WKVTHO=0 PKVTHO=0 LLODVTH=0 WLODVTH=0 STETAO=0 LODETAO=1 SCREF=1e-06 WEB=0 WEC=0 KVTHOWEO=0 KVTHOWEL=0 KVTHOWEW=0 KVTHOWELW=0 KUOWEO=0 KUOWEL=0 KUOWEW=0 KUOWELW=0 TRJ=21 SWJUNEXP=0 IMAX=0.0020128 FREV=1000 CJORBOT=0.00085856 CJORSTI=2.4557e-11 CJORGAT=1.3846e-11 VBIRBOT=0.74373 VBIRSTI=1.597 VBIRGAT=0.6629 PBOT=0.27424 PSTI=0.16571 PGAT=0.1451 CJORBOTD=0.001 CJORSTID=1e-09 CJORGATD=1e-09 VBIRBOTD=1 VBIRSTID=1 VBIRGATD=1 PBOTD=0.5 PSTID=0.5 PGATD=0.5 PHIGBOT=1.1984 PHIGSTI=1.006 PHIGGAT=0.3 IDSATRBOT=5.397e-08 IDSATRSTI=4.0612e-15 IDSATRGAT=0 CSRHBOT=100 CSRHSTI=0.0001 CSRHGAT=0.0001 XJUNSTI=1.61e-08 XJUNGAT=6.134e-07 PHIGBOTD=1.16 PHIGSTID=1.16 PHIGGATD=1.16 IDSATRBOTD=1e-12 IDSATRSTID=1e-18 IDSATRGATD=1e-18 CSRHBOTD=100 CSRHSTID=0.0001 CSRHGATD=0.0001 XJUNSTID=1e-07 XJUNGATD=1e-07 CTATBOT=100 CTATSTI=0.0001 CTATGAT=0.0001 MEFFTATBOT=0.25 MEFFTATSTI=0.25 MEFFTATGAT=0.25 CTATBOTD=100 CTATSTID=0.0001 CTATGATD=0.0001 MEFFTATBOTD=0.25 MEFFTATSTID=0.25 MEFFTATGATD=0.25 CBBTBOT=1e-12 CBBTSTI=1e-21 CBBTGAT=1e-18 FBBTRBOT=1000000000 FBBTRSTI=1000000000 FBBTRGAT=1000000000 STFBBTBOT=-0.001 STFBBTSTI=-0.001 STFBBTGAT=-0.001 CBBTBOTD=1e-12 CBBTSTID=1e-18 CBBTGATD=1e-18 FBBTRBOTD=1000000000 FBBTRSTID=1000000000 FBBTRGATD=1000000000 STFBBTBOTD=-0.001 STFBBTSTID=-0.001 STFBBTGATD=-0.001 VBRBOT=10 VBRSTI=10 VBRGAT=10 PBRBOT=4 PBRSTI=4 PBRGAT=4 VBRBOTD=10 VBRSTID=10 VBRGATD=10 PBRBOTD=4 PBRSTID=4 PBRGATD=4 VJUNREF=2.5 FJUNQ=0.03 VJUNREFD=2.5 FJUNQD=0.03 RINT=3.0856e-12 RVPOLY=0 DLSIL=0 RSH=0 RSHD=0 CFRW=1.2e-16 RSHG=20 RGO=35 RBULKO=580.3845369 RWELLO=580.3845369 RJUNSO=652.932604 RJUNDO=652.932604 SWSOA=0 VGS_MAX=3 VGD_MAX=3 VGB_MAX=3 VDS_MAX=3 VDB_MAX=1.6 VSB_MAX=1.6
model hvn_w3625n_l450n_ng1 PSP103VA TYPE=1 TR=27 DTA=0 SWGEO=1 SWIGATE=1 SWIMPACT=1 SWGIDL=0 SWJUNCAP=3 SWJUNASYM=0 SWNUD=0 SWEDGE=0 SWDELVTAC=0 SWIGN=1 QMC=1 LVARO=3.499e-08 LVARL=-0.09125 LVARW=0 LAP=6.3866e-08 WVARO=0 WVARL=0 WVARW=0 WOT=3e-08 DLQ=5.2202e-08 DWQ=3e-08 VFBO=-0.89839 VFBL=0.15096 VFBW=0.0017033 VFBLW=0.019398 STVFBO=0.0008739 STVFBL=0.00014864 STVFBW=-4.6174e-05 STVFBLW=-2.445e-06 ST2VFBO=0 TOXO=7.4256e-09 EPSROXO=3.9 NSUBO=1.8552e+23 NSUBW=-0.0050198 WSEG=1.098e-10 NPCK=3.178e+23 NPCKW=-2.7604 WSEGP=1e-08 LPCK=1e-08 LPCKW=0 FOL1=0.21033 FOL2=0.0026472 FACNEFFACO=1 FACNEFFACL=0 FACNEFFACW=0 FACNEFFACLW=0 GFACNUDO=1 GFACNUDL=0 GFACNUDLEXP=1 GFACNUDW=0 GFACNUDLW=0 VSBNUDO=0 DVSBNUDO=1 VNSUBO=0 NSLPO=0.05 DNSUBO=0.025686 DPHIBO=-0.0607576464 DPHIBL=-0.00546403785 DPHIBLEXP=2.3956 DPHIBW=0.014614 DPHIBLW=-0.017476272 DELVTACO=0 DELVTACL=0 DELVTACLEXP=1 DELVTACW=0 DELVTACLW=0 NPO=3.897e+26 NPL=-0.1215 TOXOVO=7.4256e-09 TOXOVDO=2e-09 LOV=6.3866e-08 LOVD=0 NOVO=5.5814e+24 NOVDO=5e+25 CTO=-0.061658 CTL=0.025 CTLEXP=1.6063 CTW=-0.044911 CTLW=-0.0077386 CTGO=0 CTBO=0 STCTO=1 CFL=0.0048288 CFLEXP=1.3328 CFW=0.037319 CFBO=0.26069 CFDO=0 PSCEL=0 PSCELEXP=2 PSCEW=0 PSCEBO=0 PSCEDO=0 UO=0.046687 FBET1=-0.35712 FBET1W=-0.14995 LP1=4.5615e-08 LP1W=0.4189 FBET2=-1.0245 LP2=9.42e-09 BETW1=0.6567 BETW2=-0.083639 WBET=1.0063e-10 STBETO=1.6942 STBETL=-0.0065587 STBETW=-0.060053 STBETLW=0.00036994 MUEO=0.91692524 MUEW=-0.018226 STMUEO=0.34067 THEMUO=2.5509 STTHEMUO=0.63756 CSO=2.0494 CSL=-0.97261 CSLEXP=0 CSW=0.044205 CSLW=-1.0021 STCSO=2.5545 THECSO=2 STTHECSO=0 XCORO=0.04872 XCORL=-0.27137 XCORW=-0.1948 XCORLW=0 STXCORO=1.1327 FETAO=1.0706 RSW1=321.598966 RSW2=-0.07 STRSO=-0.058157 RSBO=-0.0025425 RSGO=0.10986 THESATO=0.1 THESATL=0.446499 THESATLEXP=1.0973 THESATW=0.082797 THESATLW=-0.032897685 STTHESATO=0.48396 STTHESATL=0.50226 STTHESATW=0.049985 STTHESATLW=-0.059487 THESATBO=0.06 THESATGO=0.050814 AXO=8.7694 AXL=2.3029 ALPL=0.0019702 ALPLEXP=1.4003 ALPW=1.1052 ALP1L1=0.007475 ALP1LEXP=0.80983 ALP1L2=0.719 ALP1W=0.56703 ALP2L1=5.413e-07 ALP2LEXP=0.2541 ALP2L2=0 ALP2W=-10 VPO=0.06567 A1O=4.7288 A1L=0.052459 A1W=0.024056 A2O=22.013 STA2O=0.018532 A3O=1.2047 A3L=-0.10308 A3W=0.0069117 A4O=0.12894 A4L=-0.05413 A4W=-0.06197 GCOO=0 IGINVLW=0 IGOVW=0 IGOVDW=0 STIGO=2 GC2O=0.375 GC3O=0.063 CHIBO=3.1 AGIDLW=70 AGIDLDW=0 BGIDLO=13 BGIDLDO=41 STBGIDLO=-0.001067 STBGIDLDO=0 CGIDLO=0 CGIDLDO=0 CGBOVL=2.522e-16 CFRDW=0 FNTO=1 FNTEXCL=0 NFALW=1.42e+25 NFBLW=574300000 NFCLW=-3.015e-08 EFO=1 LINTNOI=-3.158e-08 ALPNOI=2.708 WEDGE=1e-08 WEDGEW=0 VFBEDGEO=-1 STVFBEDGEO=0.0005 STVFBEDGEL=0 STVFBEDGEW=0 STVFBEDGELW=0 DPHIBEDGEO=0 DPHIBEDGEL=0 DPHIBEDGELEXP=1 DPHIBEDGEW=0 DPHIBEDGELW=0 NSUBEDGEO=5e+23 NSUBEDGEL=0 NSUBEDGELEXP=1 NSUBEDGEW=0 NSUBEDGELW=0 CTEDGEO=0 CTEDGEL=0 CTEDGELEXP=1 FBETEDGE=0 LPEDGE=1e-08 BETEDGEW=0 STBETEDGEO=1 STBETEDGEL=0 STBETEDGEW=0 STBETEDGELW=0 PSCEEDGEL=0 PSCEEDGELEXP=2 PSCEEDGEW=0 PSCEBEDGEO=0 PSCEDEDGEO=0 CFEDGEL=0 CFEDGELEXP=2 CFEDGEW=0 CFDEDGEO=0 CFBEDGEO=0 FNTEDGEO=1 NFAEDGELW=8e+22 NFBEDGELW=30000000 NFCEDGELW=0 EFEDGEO=1 SAREF=1e-06 SBREF=1e-06 WLOD=0 KUO=0 KVSAT=0 TKUO=0 LKUO=0 WKUO=0 PKUO=0 LLODKUO=0 WLODKUO=0 KVTHO=0 LKVTHO=0 WKVTHO=0 PKVTHO=0 LLODVTH=0 WLODVTH=0 STETAO=0 LODETAO=1 SCREF=1e-06 WEB=0 WEC=0 KVTHOWEO=0 KVTHOWEL=0 KVTHOWEW=0 KVTHOWELW=0 KUOWEO=0 KUOWEL=0 KUOWEW=0 KUOWELW=0 TRJ=21 SWJUNEXP=0 IMAX=0.0020128 FREV=1000 CJORBOT=0.00085856 CJORSTI=2.4557e-11 CJORGAT=1.3846e-11 VBIRBOT=0.74373 VBIRSTI=1.597 VBIRGAT=0.6629 PBOT=0.27424 PSTI=0.16571 PGAT=0.1451 CJORBOTD=0.001 CJORSTID=1e-09 CJORGATD=1e-09 VBIRBOTD=1 VBIRSTID=1 VBIRGATD=1 PBOTD=0.5 PSTID=0.5 PGATD=0.5 PHIGBOT=1.1984 PHIGSTI=1.006 PHIGGAT=0.3 IDSATRBOT=5.397e-08 IDSATRSTI=4.0612e-15 IDSATRGAT=0 CSRHBOT=100 CSRHSTI=0.0001 CSRHGAT=0.0001 XJUNSTI=1.61e-08 XJUNGAT=6.134e-07 PHIGBOTD=1.16 PHIGSTID=1.16 PHIGGATD=1.16 IDSATRBOTD=1e-12 IDSATRSTID=1e-18 IDSATRGATD=1e-18 CSRHBOTD=100 CSRHSTID=0.0001 CSRHGATD=0.0001 XJUNSTID=1e-07 XJUNGATD=1e-07 CTATBOT=100 CTATSTI=0.0001 CTATGAT=0.0001 MEFFTATBOT=0.25 MEFFTATSTI=0.25 MEFFTATGAT=0.25 CTATBOTD=100 CTATSTID=0.0001 CTATGATD=0.0001 MEFFTATBOTD=0.25 MEFFTATSTID=0.25 MEFFTATGATD=0.25 CBBTBOT=1e-12 CBBTSTI=1e-21 CBBTGAT=1e-18 FBBTRBOT=1000000000 FBBTRSTI=1000000000 FBBTRGAT=1000000000 STFBBTBOT=-0.001 STFBBTSTI=-0.001 STFBBTGAT=-0.001 CBBTBOTD=1e-12 CBBTSTID=1e-18 CBBTGATD=1e-18 FBBTRBOTD=1000000000 FBBTRSTID=1000000000 FBBTRGATD=1000000000 STFBBTBOTD=-0.001 STFBBTSTID=-0.001 STFBBTGATD=-0.001 VBRBOT=10 VBRSTI=10 VBRGAT=10 PBRBOT=4 PBRSTI=4 PBRGAT=4 VBRBOTD=10 VBRSTID=10 VBRGATD=10 PBRBOTD=4 PBRSTID=4 PBRGATD=4 VJUNREF=2.5 FJUNQ=0.03 VJUNREFD=2.5 FJUNQD=0.03 RINT=3.0856e-12 RVPOLY=0 DLSIL=0 RSH=0 RSHD=0 CFRW=1.2e-16 RSHG=20 RGO=35 RBULKO=551.6519655 RWELLO=551.6519655 RJUNSO=620.6084612 RJUNDO=620.6084612 SWSOA=0 VGS_MAX=3 VGD_MAX=3 VGB_MAX=3 VDS_MAX=3 VDB_MAX=1.6 VSB_MAX=1.6
model hvn_w3773n_l450n_ng1 PSP103VA TYPE=1 TR=27 DTA=0 SWGEO=1 SWIGATE=1 SWIMPACT=1 SWGIDL=0 SWJUNCAP=3 SWJUNASYM=0 SWNUD=0 SWEDGE=0 SWDELVTAC=0 SWIGN=1 QMC=1 LVARO=3.499e-08 LVARL=-0.09125 LVARW=0 LAP=6.3866e-08 WVARO=0 WVARL=0 WVARW=0 WOT=3e-08 DLQ=5.2202e-08 DWQ=3e-08 VFBO=-0.89839 VFBL=0.15096 VFBW=0.0017033 VFBLW=0.019398 STVFBO=0.0008739 STVFBL=0.00014864 STVFBW=-4.6174e-05 STVFBLW=-2.445e-06 ST2VFBO=0 TOXO=7.4256e-09 EPSROXO=3.9 NSUBO=1.8552e+23 NSUBW=-0.0050198 WSEG=1.098e-10 NPCK=3.178e+23 NPCKW=-2.7604 WSEGP=1e-08 LPCK=1e-08 LPCKW=0 FOL1=0.21033 FOL2=0.0026472 FACNEFFACO=1 FACNEFFACL=0 FACNEFFACW=0 FACNEFFACLW=0 GFACNUDO=1 GFACNUDL=0 GFACNUDLEXP=1 GFACNUDW=0 GFACNUDLW=0 VSBNUDO=0 DVSBNUDO=1 VNSUBO=0 NSLPO=0.05 DNSUBO=0.025686 DPHIBO=-0.0607576464 DPHIBL=-0.00546403785 DPHIBLEXP=2.3956 DPHIBW=0.014614 DPHIBLW=-0.017476272 DELVTACO=0 DELVTACL=0 DELVTACLEXP=1 DELVTACW=0 DELVTACLW=0 NPO=3.897e+26 NPL=-0.1215 TOXOVO=7.4256e-09 TOXOVDO=2e-09 LOV=6.3866e-08 LOVD=0 NOVO=5.5814e+24 NOVDO=5e+25 CTO=-0.061658 CTL=0.025 CTLEXP=1.6063 CTW=-0.044911 CTLW=-0.0077386 CTGO=0 CTBO=0 STCTO=1 CFL=0.0048288 CFLEXP=1.3328 CFW=0.037319 CFBO=0.26069 CFDO=0 PSCEL=0 PSCELEXP=2 PSCEW=0 PSCEBO=0 PSCEDO=0 UO=0.046687 FBET1=-0.35712 FBET1W=-0.14995 LP1=4.5615e-08 LP1W=0.4189 FBET2=-1.0245 LP2=9.42e-09 BETW1=0.6567 BETW2=-0.083639 WBET=1.0063e-10 STBETO=1.6942 STBETL=-0.0065587 STBETW=-0.060053 STBETLW=0.00036994 MUEO=0.91692524 MUEW=-0.018226 STMUEO=0.34067 THEMUO=2.5509 STTHEMUO=0.63756 CSO=2.0494 CSL=-0.97261 CSLEXP=0 CSW=0.044205 CSLW=-1.0021 STCSO=2.5545 THECSO=2 STTHECSO=0 XCORO=0.04872 XCORL=-0.27137 XCORW=-0.1948 XCORLW=0 STXCORO=1.1327 FETAO=1.0706 RSW1=321.598966 RSW2=-0.07 STRSO=-0.058157 RSBO=-0.0025425 RSGO=0.10986 THESATO=0.1 THESATL=0.446499 THESATLEXP=1.0973 THESATW=0.082797 THESATLW=-0.032897685 STTHESATO=0.48396 STTHESATL=0.50226 STTHESATW=0.049985 STTHESATLW=-0.059487 THESATBO=0.06 THESATGO=0.050814 AXO=8.7694 AXL=2.3029 ALPL=0.0019702 ALPLEXP=1.4003 ALPW=1.1052 ALP1L1=0.007475 ALP1LEXP=0.80983 ALP1L2=0.719 ALP1W=0.56703 ALP2L1=5.413e-07 ALP2LEXP=0.2541 ALP2L2=0 ALP2W=-10 VPO=0.06567 A1O=4.7288 A1L=0.052459 A1W=0.024056 A2O=22.013 STA2O=0.018532 A3O=1.2047 A3L=-0.10308 A3W=0.0069117 A4O=0.12894 A4L=-0.05413 A4W=-0.06197 GCOO=0 IGINVLW=0 IGOVW=0 IGOVDW=0 STIGO=2 GC2O=0.375 GC3O=0.063 CHIBO=3.1 AGIDLW=70 AGIDLDW=0 BGIDLO=13 BGIDLDO=41 STBGIDLO=-0.001067 STBGIDLDO=0 CGIDLO=0 CGIDLDO=0 CGBOVL=2.522e-16 CFRDW=0 FNTO=1 FNTEXCL=0 NFALW=1.42e+25 NFBLW=574300000 NFCLW=-3.015e-08 EFO=1 LINTNOI=-3.158e-08 ALPNOI=2.708 WEDGE=1e-08 WEDGEW=0 VFBEDGEO=-1 STVFBEDGEO=0.0005 STVFBEDGEL=0 STVFBEDGEW=0 STVFBEDGELW=0 DPHIBEDGEO=0 DPHIBEDGEL=0 DPHIBEDGELEXP=1 DPHIBEDGEW=0 DPHIBEDGELW=0 NSUBEDGEO=5e+23 NSUBEDGEL=0 NSUBEDGELEXP=1 NSUBEDGEW=0 NSUBEDGELW=0 CTEDGEO=0 CTEDGEL=0 CTEDGELEXP=1 FBETEDGE=0 LPEDGE=1e-08 BETEDGEW=0 STBETEDGEO=1 STBETEDGEL=0 STBETEDGEW=0 STBETEDGELW=0 PSCEEDGEL=0 PSCEEDGELEXP=2 PSCEEDGEW=0 PSCEBEDGEO=0 PSCEDEDGEO=0 CFEDGEL=0 CFEDGELEXP=2 CFEDGEW=0 CFDEDGEO=0 CFBEDGEO=0 FNTEDGEO=1 NFAEDGELW=8e+22 NFBEDGELW=30000000 NFCEDGELW=0 EFEDGEO=1 SAREF=1e-06 SBREF=1e-06 WLOD=0 KUO=0 KVSAT=0 TKUO=0 LKUO=0 WKUO=0 PKUO=0 LLODKUO=0 WLODKUO=0 KVTHO=0 LKVTHO=0 WKVTHO=0 PKVTHO=0 LLODVTH=0 WLODVTH=0 STETAO=0 LODETAO=1 SCREF=1e-06 WEB=0 WEC=0 KVTHOWEO=0 KVTHOWEL=0 KVTHOWEW=0 KVTHOWELW=0 KUOWEO=0 KUOWEL=0 KUOWEW=0 KUOWELW=0 TRJ=21 SWJUNEXP=0 IMAX=0.0020128 FREV=1000 CJORBOT=0.00085856 CJORSTI=2.4557e-11 CJORGAT=1.3846e-11 VBIRBOT=0.74373 VBIRSTI=1.597 VBIRGAT=0.6629 PBOT=0.27424 PSTI=0.16571 PGAT=0.1451 CJORBOTD=0.001 CJORSTID=1e-09 CJORGATD=1e-09 VBIRBOTD=1 VBIRSTID=1 VBIRGATD=1 PBOTD=0.5 PSTID=0.5 PGATD=0.5 PHIGBOT=1.1984 PHIGSTI=1.006 PHIGGAT=0.3 IDSATRBOT=5.397e-08 IDSATRSTI=4.0612e-15 IDSATRGAT=0 CSRHBOT=100 CSRHSTI=0.0001 CSRHGAT=0.0001 XJUNSTI=1.61e-08 XJUNGAT=6.134e-07 PHIGBOTD=1.16 PHIGSTID=1.16 PHIGGATD=1.16 IDSATRBOTD=1e-12 IDSATRSTID=1e-18 IDSATRGATD=1e-18 CSRHBOTD=100 CSRHSTID=0.0001 CSRHGATD=0.0001 XJUNSTID=1e-07 XJUNGATD=1e-07 CTATBOT=100 CTATSTI=0.0001 CTATGAT=0.0001 MEFFTATBOT=0.25 MEFFTATSTI=0.25 MEFFTATGAT=0.25 CTATBOTD=100 CTATSTID=0.0001 CTATGATD=0.0001 MEFFTATBOTD=0.25 MEFFTATSTID=0.25 MEFFTATGATD=0.25 CBBTBOT=1e-12 CBBTSTI=1e-21 CBBTGAT=1e-18 FBBTRBOT=1000000000 FBBTRSTI=1000000000 FBBTRGAT=1000000000 STFBBTBOT=-0.001 STFBBTSTI=-0.001 STFBBTGAT=-0.001 CBBTBOTD=1e-12 CBBTSTID=1e-18 CBBTGATD=1e-18 FBBTRBOTD=1000000000 FBBTRSTID=1000000000 FBBTRGATD=1000000000 STFBBTBOTD=-0.001 STFBBTSTID=-0.001 STFBBTGATD=-0.001 VBRBOT=10 VBRSTI=10 VBRGAT=10 PBRBOT=4 PBRSTI=4 PBRGAT=4 VBRBOTD=10 VBRSTID=10 VBRGATD=10 PBRBOTD=4 PBRSTID=4 PBRGATD=4 VJUNREF=2.5 FJUNQ=0.03 VJUNREFD=2.5 FJUNQD=0.03 RINT=3.0856e-12 RVPOLY=0 DLSIL=0 RSH=0 RSHD=0 CFRW=1.2e-16 RSHG=20 RGO=35 RBULKO=530.147287 RWELLO=530.147287 RJUNSO=596.4156978 RJUNDO=596.4156978 SWSOA=0 VGS_MAX=3 VGD_MAX=3 VGB_MAX=3 VDS_MAX=3 VDB_MAX=1.6 VSB_MAX=1.6
model hvn_w4000n_l1000n_ng1 PSP103VA TYPE=1 TR=27 DTA=0 SWGEO=1 SWIGATE=1 SWIMPACT=1 SWGIDL=0 SWJUNCAP=3 SWJUNASYM=0 SWNUD=0 SWEDGE=0 SWDELVTAC=0 SWIGN=1 QMC=1 LVARO=3.499e-08 LVARL=-0.09125 LVARW=0 LAP=6.3866e-08 WVARO=0 WVARL=0 WVARW=0 WOT=3e-08 DLQ=5.2202e-08 DWQ=3e-08 VFBO=-0.89839 VFBL=0.15096 VFBW=0.0017033 VFBLW=0.019398 STVFBO=0.0008739 STVFBL=0.00014864 STVFBW=-4.6174e-05 STVFBLW=-2.445e-06 ST2VFBO=0 TOXO=7.4256e-09 EPSROXO=3.9 NSUBO=1.8552e+23 NSUBW=-0.0050198 WSEG=1.098e-10 NPCK=3.178e+23 NPCKW=-2.7604 WSEGP=1e-08 LPCK=1e-08 LPCKW=0 FOL1=0.21033 FOL2=0.0026472 FACNEFFACO=1 FACNEFFACL=0 FACNEFFACW=0 FACNEFFACLW=0 GFACNUDO=1 GFACNUDL=0 GFACNUDLEXP=1 GFACNUDW=0 GFACNUDLW=0 VSBNUDO=0 DVSBNUDO=1 VNSUBO=0 NSLPO=0.05 DNSUBO=0.025686 DPHIBO=-0.0607576464 DPHIBL=-0.00546403785 DPHIBLEXP=2.3956 DPHIBW=0.014614 DPHIBLW=-0.017476272 DELVTACO=0 DELVTACL=0 DELVTACLEXP=1 DELVTACW=0 DELVTACLW=0 NPO=3.897e+26 NPL=-0.1215 TOXOVO=7.4256e-09 TOXOVDO=2e-09 LOV=6.3866e-08 LOVD=0 NOVO=5.5814e+24 NOVDO=5e+25 CTO=-0.061658 CTL=0.025 CTLEXP=1.6063 CTW=-0.044911 CTLW=-0.0077386 CTGO=0 CTBO=0 STCTO=1 CFL=0.0048288 CFLEXP=1.3328 CFW=0.037319 CFBO=0.26069 CFDO=0 PSCEL=0 PSCELEXP=2 PSCEW=0 PSCEBO=0 PSCEDO=0 UO=0.046687 FBET1=-0.35712 FBET1W=-0.14995 LP1=4.5615e-08 LP1W=0.4189 FBET2=-1.0245 LP2=9.42e-09 BETW1=0.6567 BETW2=-0.083639 WBET=1.0063e-10 STBETO=1.6942 STBETL=-0.0065587 STBETW=-0.060053 STBETLW=0.00036994 MUEO=0.91692524 MUEW=-0.018226 STMUEO=0.34067 THEMUO=2.5509 STTHEMUO=0.63756 CSO=2.0494 CSL=-0.97261 CSLEXP=0 CSW=0.044205 CSLW=-1.0021 STCSO=2.5545 THECSO=2 STTHECSO=0 XCORO=0.04872 XCORL=-0.27137 XCORW=-0.1948 XCORLW=0 STXCORO=1.1327 FETAO=1.0706 RSW1=321.598966 RSW2=-0.07 STRSO=-0.058157 RSBO=-0.0025425 RSGO=0.10986 THESATO=0.1 THESATL=0.446499 THESATLEXP=1.0973 THESATW=0.082797 THESATLW=-0.032897685 STTHESATO=0.48396 STTHESATL=0.50226 STTHESATW=0.049985 STTHESATLW=-0.059487 THESATBO=0.06 THESATGO=0.050814 AXO=8.7694 AXL=2.3029 ALPL=0.0019702 ALPLEXP=1.4003 ALPW=1.1052 ALP1L1=0.007475 ALP1LEXP=0.80983 ALP1L2=0.719 ALP1W=0.56703 ALP2L1=5.413e-07 ALP2LEXP=0.2541 ALP2L2=0 ALP2W=-10 VPO=0.06567 A1O=4.7288 A1L=0.052459 A1W=0.024056 A2O=22.013 STA2O=0.018532 A3O=1.2047 A3L=-0.10308 A3W=0.0069117 A4O=0.12894 A4L=-0.05413 A4W=-0.06197 GCOO=0 IGINVLW=0 IGOVW=0 IGOVDW=0 STIGO=2 GC2O=0.375 GC3O=0.063 CHIBO=3.1 AGIDLW=70 AGIDLDW=0 BGIDLO=13 BGIDLDO=41 STBGIDLO=-0.001067 STBGIDLDO=0 CGIDLO=0 CGIDLDO=0 CGBOVL=2.522e-16 CFRDW=0 FNTO=1 FNTEXCL=0 NFALW=1.42e+25 NFBLW=574300000 NFCLW=-3.015e-08 EFO=1 LINTNOI=-3.158e-08 ALPNOI=2.708 WEDGE=1e-08 WEDGEW=0 VFBEDGEO=-1 STVFBEDGEO=0.0005 STVFBEDGEL=0 STVFBEDGEW=0 STVFBEDGELW=0 DPHIBEDGEO=0 DPHIBEDGEL=0 DPHIBEDGELEXP=1 DPHIBEDGEW=0 DPHIBEDGELW=0 NSUBEDGEO=5e+23 NSUBEDGEL=0 NSUBEDGELEXP=1 NSUBEDGEW=0 NSUBEDGELW=0 CTEDGEO=0 CTEDGEL=0 CTEDGELEXP=1 FBETEDGE=0 LPEDGE=1e-08 BETEDGEW=0 STBETEDGEO=1 STBETEDGEL=0 STBETEDGEW=0 STBETEDGELW=0 PSCEEDGEL=0 PSCEEDGELEXP=2 PSCEEDGEW=0 PSCEBEDGEO=0 PSCEDEDGEO=0 CFEDGEL=0 CFEDGELEXP=2 CFEDGEW=0 CFDEDGEO=0 CFBEDGEO=0 FNTEDGEO=1 NFAEDGELW=8e+22 NFBEDGELW=30000000 NFCEDGELW=0 EFEDGEO=1 SAREF=1e-06 SBREF=1e-06 WLOD=0 KUO=0 KVSAT=0 TKUO=0 LKUO=0 WKUO=0 PKUO=0 LLODKUO=0 WLODKUO=0 KVTHO=0 LKVTHO=0 WKVTHO=0 PKVTHO=0 LLODVTH=0 WLODVTH=0 STETAO=0 LODETAO=1 SCREF=1e-06 WEB=0 WEC=0 KVTHOWEO=0 KVTHOWEL=0 KVTHOWEW=0 KVTHOWELW=0 KUOWEO=0 KUOWEL=0 KUOWEW=0 KUOWELW=0 TRJ=21 SWJUNEXP=0 IMAX=0.0020128 FREV=1000 CJORBOT=0.00085856 CJORSTI=2.4557e-11 CJORGAT=1.3846e-11 VBIRBOT=0.74373 VBIRSTI=1.597 VBIRGAT=0.6629 PBOT=0.27424 PSTI=0.16571 PGAT=0.1451 CJORBOTD=0.001 CJORSTID=1e-09 CJORGATD=1e-09 VBIRBOTD=1 VBIRSTID=1 VBIRGATD=1 PBOTD=0.5 PSTID=0.5 PGATD=0.5 PHIGBOT=1.1984 PHIGSTI=1.006 PHIGGAT=0.3 IDSATRBOT=5.397e-08 IDSATRSTI=4.0612e-15 IDSATRGAT=0 CSRHBOT=100 CSRHSTI=0.0001 CSRHGAT=0.0001 XJUNSTI=1.61e-08 XJUNGAT=6.134e-07 PHIGBOTD=1.16 PHIGSTID=1.16 PHIGGATD=1.16 IDSATRBOTD=1e-12 IDSATRSTID=1e-18 IDSATRGATD=1e-18 CSRHBOTD=100 CSRHSTID=0.0001 CSRHGATD=0.0001 XJUNSTID=1e-07 XJUNGATD=1e-07 CTATBOT=100 CTATSTI=0.0001 CTATGAT=0.0001 MEFFTATBOT=0.25 MEFFTATSTI=0.25 MEFFTATGAT=0.25 CTATBOTD=100 CTATSTID=0.0001 CTATGATD=0.0001 MEFFTATBOTD=0.25 MEFFTATSTID=0.25 MEFFTATGATD=0.25 CBBTBOT=1e-12 CBBTSTI=1e-21 CBBTGAT=1e-18 FBBTRBOT=1000000000 FBBTRSTI=1000000000 FBBTRGAT=1000000000 STFBBTBOT=-0.001 STFBBTSTI=-0.001 STFBBTGAT=-0.001 CBBTBOTD=1e-12 CBBTSTID=1e-18 CBBTGATD=1e-18 FBBTRBOTD=1000000000 FBBTRSTID=1000000000 FBBTRGATD=1000000000 STFBBTBOTD=-0.001 STFBBTSTID=-0.001 STFBBTGATD=-0.001 VBRBOT=10 VBRSTI=10 VBRGAT=10 PBRBOT=4 PBRSTI=4 PBRGAT=4 VBRBOTD=10 VBRSTID=10 VBRGATD=10 PBRBOTD=4 PBRSTID=4 PBRGATD=4 VJUNREF=2.5 FJUNQ=0.03 VJUNREFD=2.5 FJUNQD=0.03 RINT=3.0856e-12 RVPOLY=0 DLSIL=0 RSH=0 RSHD=0 CFRW=1.2e-16 RSHG=20 RGO=35 RBULKO=500 RWELLO=500 RJUNSO=1250 RJUNDO=1250 SWSOA=0 VGS_MAX=3 VGD_MAX=3 VGB_MAX=3 VDS_MAX=3 VDB_MAX=1.6 VSB_MAX=1.6
model hvn_w5683n_l450n_ng1 PSP103VA TYPE=1 TR=27 DTA=0 SWGEO=1 SWIGATE=1 SWIMPACT=1 SWGIDL=0 SWJUNCAP=3 SWJUNASYM=0 SWNUD=0 SWEDGE=0 SWDELVTAC=0 SWIGN=1 QMC=1 LVARO=3.499e-08 LVARL=-0.09125 LVARW=0 LAP=6.3866e-08 WVARO=0 WVARL=0 WVARW=0 WOT=3e-08 DLQ=5.2202e-08 DWQ=3e-08 VFBO=-0.89839 VFBL=0.15096 VFBW=0.0017033 VFBLW=0.019398 STVFBO=0.0008739 STVFBL=0.00014864 STVFBW=-4.6174e-05 STVFBLW=-2.445e-06 ST2VFBO=0 TOXO=7.4256e-09 EPSROXO=3.9 NSUBO=1.8552e+23 NSUBW=-0.0050198 WSEG=1.098e-10 NPCK=3.178e+23 NPCKW=-2.7604 WSEGP=1e-08 LPCK=1e-08 LPCKW=0 FOL1=0.21033 FOL2=0.0026472 FACNEFFACO=1 FACNEFFACL=0 FACNEFFACW=0 FACNEFFACLW=0 GFACNUDO=1 GFACNUDL=0 GFACNUDLEXP=1 GFACNUDW=0 GFACNUDLW=0 VSBNUDO=0 DVSBNUDO=1 VNSUBO=0 NSLPO=0.05 DNSUBO=0.025686 DPHIBO=-0.0607576464 DPHIBL=-0.00546403785 DPHIBLEXP=2.3956 DPHIBW=0.014614 DPHIBLW=-0.017476272 DELVTACO=0 DELVTACL=0 DELVTACLEXP=1 DELVTACW=0 DELVTACLW=0 NPO=3.897e+26 NPL=-0.1215 TOXOVO=7.4256e-09 TOXOVDO=2e-09 LOV=6.3866e-08 LOVD=0 NOVO=5.5814e+24 NOVDO=5e+25 CTO=-0.061658 CTL=0.025 CTLEXP=1.6063 CTW=-0.044911 CTLW=-0.0077386 CTGO=0 CTBO=0 STCTO=1 CFL=0.0048288 CFLEXP=1.3328 CFW=0.037319 CFBO=0.26069 CFDO=0 PSCEL=0 PSCELEXP=2 PSCEW=0 PSCEBO=0 PSCEDO=0 UO=0.046687 FBET1=-0.35712 FBET1W=-0.14995 LP1=4.5615e-08 LP1W=0.4189 FBET2=-1.0245 LP2=9.42e-09 BETW1=0.6567 BETW2=-0.083639 WBET=1.0063e-10 STBETO=1.6942 STBETL=-0.0065587 STBETW=-0.060053 STBETLW=0.00036994 MUEO=0.91692524 MUEW=-0.018226 STMUEO=0.34067 THEMUO=2.5509 STTHEMUO=0.63756 CSO=2.0494 CSL=-0.97261 CSLEXP=0 CSW=0.044205 CSLW=-1.0021 STCSO=2.5545 THECSO=2 STTHECSO=0 XCORO=0.04872 XCORL=-0.27137 XCORW=-0.1948 XCORLW=0 STXCORO=1.1327 FETAO=1.0706 RSW1=321.598966 RSW2=-0.07 STRSO=-0.058157 RSBO=-0.0025425 RSGO=0.10986 THESATO=0.1 THESATL=0.446499 THESATLEXP=1.0973 THESATW=0.082797 THESATLW=-0.032897685 STTHESATO=0.48396 STTHESATL=0.50226 STTHESATW=0.049985 STTHESATLW=-0.059487 THESATBO=0.06 THESATGO=0.050814 AXO=8.7694 AXL=2.3029 ALPL=0.0019702 ALPLEXP=1.4003 ALPW=1.1052 ALP1L1=0.007475 ALP1LEXP=0.80983 ALP1L2=0.719 ALP1W=0.56703 ALP2L1=5.413e-07 ALP2LEXP=0.2541 ALP2L2=0 ALP2W=-10 VPO=0.06567 A1O=4.7288 A1L=0.052459 A1W=0.024056 A2O=22.013 STA2O=0.018532 A3O=1.2047 A3L=-0.10308 A3W=0.0069117 A4O=0.12894 A4L=-0.05413 A4W=-0.06197 GCOO=0 IGINVLW=0 IGOVW=0 IGOVDW=0 STIGO=2 GC2O=0.375 GC3O=0.063 CHIBO=3.1 AGIDLW=70 AGIDLDW=0 BGIDLO=13 BGIDLDO=41 STBGIDLO=-0.001067 STBGIDLDO=0 CGIDLO=0 CGIDLDO=0 CGBOVL=2.522e-16 CFRDW=0 FNTO=1 FNTEXCL=0 NFALW=1.42e+25 NFBLW=574300000 NFCLW=-3.015e-08 EFO=1 LINTNOI=-3.158e-08 ALPNOI=2.708 WEDGE=1e-08 WEDGEW=0 VFBEDGEO=-1 STVFBEDGEO=0.0005 STVFBEDGEL=0 STVFBEDGEW=0 STVFBEDGELW=0 DPHIBEDGEO=0 DPHIBEDGEL=0 DPHIBEDGELEXP=1 DPHIBEDGEW=0 DPHIBEDGELW=0 NSUBEDGEO=5e+23 NSUBEDGEL=0 NSUBEDGELEXP=1 NSUBEDGEW=0 NSUBEDGELW=0 CTEDGEO=0 CTEDGEL=0 CTEDGELEXP=1 FBETEDGE=0 LPEDGE=1e-08 BETEDGEW=0 STBETEDGEO=1 STBETEDGEL=0 STBETEDGEW=0 STBETEDGELW=0 PSCEEDGEL=0 PSCEEDGELEXP=2 PSCEEDGEW=0 PSCEBEDGEO=0 PSCEDEDGEO=0 CFEDGEL=0 CFEDGELEXP=2 CFEDGEW=0 CFDEDGEO=0 CFBEDGEO=0 FNTEDGEO=1 NFAEDGELW=8e+22 NFBEDGELW=30000000 NFCEDGELW=0 EFEDGEO=1 SAREF=1e-06 SBREF=1e-06 WLOD=0 KUO=0 KVSAT=0 TKUO=0 LKUO=0 WKUO=0 PKUO=0 LLODKUO=0 WLODKUO=0 KVTHO=0 LKVTHO=0 WKVTHO=0 PKVTHO=0 LLODVTH=0 WLODVTH=0 STETAO=0 LODETAO=1 SCREF=1e-06 WEB=0 WEC=0 KVTHOWEO=0 KVTHOWEL=0 KVTHOWEW=0 KVTHOWELW=0 KUOWEO=0 KUOWEL=0 KUOWEW=0 KUOWELW=0 TRJ=21 SWJUNEXP=0 IMAX=0.0020128 FREV=1000 CJORBOT=0.00085856 CJORSTI=2.4557e-11 CJORGAT=1.3846e-11 VBIRBOT=0.74373 VBIRSTI=1.597 VBIRGAT=0.6629 PBOT=0.27424 PSTI=0.16571 PGAT=0.1451 CJORBOTD=0.001 CJORSTID=1e-09 CJORGATD=1e-09 VBIRBOTD=1 VBIRSTID=1 VBIRGATD=1 PBOTD=0.5 PSTID=0.5 PGATD=0.5 PHIGBOT=1.1984 PHIGSTI=1.006 PHIGGAT=0.3 IDSATRBOT=5.397e-08 IDSATRSTI=4.0612e-15 IDSATRGAT=0 CSRHBOT=100 CSRHSTI=0.0001 CSRHGAT=0.0001 XJUNSTI=1.61e-08 XJUNGAT=6.134e-07 PHIGBOTD=1.16 PHIGSTID=1.16 PHIGGATD=1.16 IDSATRBOTD=1e-12 IDSATRSTID=1e-18 IDSATRGATD=1e-18 CSRHBOTD=100 CSRHSTID=0.0001 CSRHGATD=0.0001 XJUNSTID=1e-07 XJUNGATD=1e-07 CTATBOT=100 CTATSTI=0.0001 CTATGAT=0.0001 MEFFTATBOT=0.25 MEFFTATSTI=0.25 MEFFTATGAT=0.25 CTATBOTD=100 CTATSTID=0.0001 CTATGATD=0.0001 MEFFTATBOTD=0.25 MEFFTATSTID=0.25 MEFFTATGATD=0.25 CBBTBOT=1e-12 CBBTSTI=1e-21 CBBTGAT=1e-18 FBBTRBOT=1000000000 FBBTRSTI=1000000000 FBBTRGAT=1000000000 STFBBTBOT=-0.001 STFBBTSTI=-0.001 STFBBTGAT=-0.001 CBBTBOTD=1e-12 CBBTSTID=1e-18 CBBTGATD=1e-18 FBBTRBOTD=1000000000 FBBTRSTID=1000000000 FBBTRGATD=1000000000 STFBBTBOTD=-0.001 STFBBTSTID=-0.001 STFBBTGATD=-0.001 VBRBOT=10 VBRSTI=10 VBRGAT=10 PBRBOT=4 PBRSTI=4 PBRGAT=4 VBRBOTD=10 VBRSTID=10 VBRGATD=10 PBRBOTD=4 PBRSTID=4 PBRGATD=4 VJUNREF=2.5 FJUNQ=0.03 VJUNREFD=2.5 FJUNQD=0.03 RINT=3.0856e-12 RVPOLY=0 DLSIL=0 RSH=0 RSHD=0 CFRW=1.2e-16 RSHG=20 RGO=35 RBULKO=351.8976 RWELLO=351.8976 RJUNSO=395.8848 RJUNDO=395.8848 SWSOA=0 VGS_MAX=3 VGD_MAX=3 VGB_MAX=3 VDS_MAX=3 VDB_MAX=1.6 VSB_MAX=1.6
model hvn_w5755n_l450n_ng1 PSP103VA TYPE=1 TR=27 DTA=0 SWGEO=1 SWIGATE=1 SWIMPACT=1 SWGIDL=0 SWJUNCAP=3 SWJUNASYM=0 SWNUD=0 SWEDGE=0 SWDELVTAC=0 SWIGN=1 QMC=1 LVARO=3.499e-08 LVARL=-0.09125 LVARW=0 LAP=6.3866e-08 WVARO=0 WVARL=0 WVARW=0 WOT=3e-08 DLQ=5.2202e-08 DWQ=3e-08 VFBO=-0.89839 VFBL=0.15096 VFBW=0.0017033 VFBLW=0.019398 STVFBO=0.0008739 STVFBL=0.00014864 STVFBW=-4.6174e-05 STVFBLW=-2.445e-06 ST2VFBO=0 TOXO=7.4256e-09 EPSROXO=3.9 NSUBO=1.8552e+23 NSUBW=-0.0050198 WSEG=1.098e-10 NPCK=3.178e+23 NPCKW=-2.7604 WSEGP=1e-08 LPCK=1e-08 LPCKW=0 FOL1=0.21033 FOL2=0.0026472 FACNEFFACO=1 FACNEFFACL=0 FACNEFFACW=0 FACNEFFACLW=0 GFACNUDO=1 GFACNUDL=0 GFACNUDLEXP=1 GFACNUDW=0 GFACNUDLW=0 VSBNUDO=0 DVSBNUDO=1 VNSUBO=0 NSLPO=0.05 DNSUBO=0.025686 DPHIBO=-0.0607576464 DPHIBL=-0.00546403785 DPHIBLEXP=2.3956 DPHIBW=0.014614 DPHIBLW=-0.017476272 DELVTACO=0 DELVTACL=0 DELVTACLEXP=1 DELVTACW=0 DELVTACLW=0 NPO=3.897e+26 NPL=-0.1215 TOXOVO=7.4256e-09 TOXOVDO=2e-09 LOV=6.3866e-08 LOVD=0 NOVO=5.5814e+24 NOVDO=5e+25 CTO=-0.061658 CTL=0.025 CTLEXP=1.6063 CTW=-0.044911 CTLW=-0.0077386 CTGO=0 CTBO=0 STCTO=1 CFL=0.0048288 CFLEXP=1.3328 CFW=0.037319 CFBO=0.26069 CFDO=0 PSCEL=0 PSCELEXP=2 PSCEW=0 PSCEBO=0 PSCEDO=0 UO=0.046687 FBET1=-0.35712 FBET1W=-0.14995 LP1=4.5615e-08 LP1W=0.4189 FBET2=-1.0245 LP2=9.42e-09 BETW1=0.6567 BETW2=-0.083639 WBET=1.0063e-10 STBETO=1.6942 STBETL=-0.0065587 STBETW=-0.060053 STBETLW=0.00036994 MUEO=0.91692524 MUEW=-0.018226 STMUEO=0.34067 THEMUO=2.5509 STTHEMUO=0.63756 CSO=2.0494 CSL=-0.97261 CSLEXP=0 CSW=0.044205 CSLW=-1.0021 STCSO=2.5545 THECSO=2 STTHECSO=0 XCORO=0.04872 XCORL=-0.27137 XCORW=-0.1948 XCORLW=0 STXCORO=1.1327 FETAO=1.0706 RSW1=321.598966 RSW2=-0.07 STRSO=-0.058157 RSBO=-0.0025425 RSGO=0.10986 THESATO=0.1 THESATL=0.446499 THESATLEXP=1.0973 THESATW=0.082797 THESATLW=-0.032897685 STTHESATO=0.48396 STTHESATL=0.50226 STTHESATW=0.049985 STTHESATLW=-0.059487 THESATBO=0.06 THESATGO=0.050814 AXO=8.7694 AXL=2.3029 ALPL=0.0019702 ALPLEXP=1.4003 ALPW=1.1052 ALP1L1=0.007475 ALP1LEXP=0.80983 ALP1L2=0.719 ALP1W=0.56703 ALP2L1=5.413e-07 ALP2LEXP=0.2541 ALP2L2=0 ALP2W=-10 VPO=0.06567 A1O=4.7288 A1L=0.052459 A1W=0.024056 A2O=22.013 STA2O=0.018532 A3O=1.2047 A3L=-0.10308 A3W=0.0069117 A4O=0.12894 A4L=-0.05413 A4W=-0.06197 GCOO=0 IGINVLW=0 IGOVW=0 IGOVDW=0 STIGO=2 GC2O=0.375 GC3O=0.063 CHIBO=3.1 AGIDLW=70 AGIDLDW=0 BGIDLO=13 BGIDLDO=41 STBGIDLO=-0.001067 STBGIDLDO=0 CGIDLO=0 CGIDLDO=0 CGBOVL=2.522e-16 CFRDW=0 FNTO=1 FNTEXCL=0 NFALW=1.42e+25 NFBLW=574300000 NFCLW=-3.015e-08 EFO=1 LINTNOI=-3.158e-08 ALPNOI=2.708 WEDGE=1e-08 WEDGEW=0 VFBEDGEO=-1 STVFBEDGEO=0.0005 STVFBEDGEL=0 STVFBEDGEW=0 STVFBEDGELW=0 DPHIBEDGEO=0 DPHIBEDGEL=0 DPHIBEDGELEXP=1 DPHIBEDGEW=0 DPHIBEDGELW=0 NSUBEDGEO=5e+23 NSUBEDGEL=0 NSUBEDGELEXP=1 NSUBEDGEW=0 NSUBEDGELW=0 CTEDGEO=0 CTEDGEL=0 CTEDGELEXP=1 FBETEDGE=0 LPEDGE=1e-08 BETEDGEW=0 STBETEDGEO=1 STBETEDGEL=0 STBETEDGEW=0 STBETEDGELW=0 PSCEEDGEL=0 PSCEEDGELEXP=2 PSCEEDGEW=0 PSCEBEDGEO=0 PSCEDEDGEO=0 CFEDGEL=0 CFEDGELEXP=2 CFEDGEW=0 CFDEDGEO=0 CFBEDGEO=0 FNTEDGEO=1 NFAEDGELW=8e+22 NFBEDGELW=30000000 NFCEDGELW=0 EFEDGEO=1 SAREF=1e-06 SBREF=1e-06 WLOD=0 KUO=0 KVSAT=0 TKUO=0 LKUO=0 WKUO=0 PKUO=0 LLODKUO=0 WLODKUO=0 KVTHO=0 LKVTHO=0 WKVTHO=0 PKVTHO=0 LLODVTH=0 WLODVTH=0 STETAO=0 LODETAO=1 SCREF=1e-06 WEB=0 WEC=0 KVTHOWEO=0 KVTHOWEL=0 KVTHOWEW=0 KVTHOWELW=0 KUOWEO=0 KUOWEL=0 KUOWEW=0 KUOWELW=0 TRJ=21 SWJUNEXP=0 IMAX=0.0020128 FREV=1000 CJORBOT=0.00085856 CJORSTI=2.4557e-11 CJORGAT=1.3846e-11 VBIRBOT=0.74373 VBIRSTI=1.597 VBIRGAT=0.6629 PBOT=0.27424 PSTI=0.16571 PGAT=0.1451 CJORBOTD=0.001 CJORSTID=1e-09 CJORGATD=1e-09 VBIRBOTD=1 VBIRSTID=1 VBIRGATD=1 PBOTD=0.5 PSTID=0.5 PGATD=0.5 PHIGBOT=1.1984 PHIGSTI=1.006 PHIGGAT=0.3 IDSATRBOT=5.397e-08 IDSATRSTI=4.0612e-15 IDSATRGAT=0 CSRHBOT=100 CSRHSTI=0.0001 CSRHGAT=0.0001 XJUNSTI=1.61e-08 XJUNGAT=6.134e-07 PHIGBOTD=1.16 PHIGSTID=1.16 PHIGGATD=1.16 IDSATRBOTD=1e-12 IDSATRSTID=1e-18 IDSATRGATD=1e-18 CSRHBOTD=100 CSRHSTID=0.0001 CSRHGATD=0.0001 XJUNSTID=1e-07 XJUNGATD=1e-07 CTATBOT=100 CTATSTI=0.0001 CTATGAT=0.0001 MEFFTATBOT=0.25 MEFFTATSTI=0.25 MEFFTATGAT=0.25 CTATBOTD=100 CTATSTID=0.0001 CTATGATD=0.0001 MEFFTATBOTD=0.25 MEFFTATSTID=0.25 MEFFTATGATD=0.25 CBBTBOT=1e-12 CBBTSTI=1e-21 CBBTGAT=1e-18 FBBTRBOT=1000000000 FBBTRSTI=1000000000 FBBTRGAT=1000000000 STFBBTBOT=-0.001 STFBBTSTI=-0.001 STFBBTGAT=-0.001 CBBTBOTD=1e-12 CBBTSTID=1e-18 CBBTGATD=1e-18 FBBTRBOTD=1000000000 FBBTRSTID=1000000000 FBBTRGATD=1000000000 STFBBTBOTD=-0.001 STFBBTSTID=-0.001 STFBBTGATD=-0.001 VBRBOT=10 VBRSTI=10 VBRGAT=10 PBRBOT=4 PBRSTI=4 PBRGAT=4 VBRBOTD=10 VBRSTID=10 VBRGATD=10 PBRBOTD=4 PBRSTID=4 PBRGATD=4 VJUNREF=2.5 FJUNQ=0.03 VJUNREFD=2.5 FJUNQD=0.03 RINT=3.0856e-12 RVPOLY=0 DLSIL=0 RSH=0 RSHD=0 CFRW=1.2e-16 RSHG=20 RGO=35 RBULKO=347.5531852 RWELLO=347.5531852 RJUNSO=390.9973333 RJUNDO=390.9973333 SWSOA=0 VGS_MAX=3 VGD_MAX=3 VGB_MAX=3 VDS_MAX=3 VDB_MAX=1.6 VSB_MAX=1.6
model hvp_w10000n_l400n_ng1 PSP103VA TYPE=-1 TR=27 DTA=0 SWGEO=1 SWIGATE=1 SWIMPACT=1 SWGIDL=1 SWJUNCAP=3 SWJUNASYM=0 SWNUD=0 SWEDGE=0 SWDELVTAC=0 SWIGN=1 QMC=1 LVARO=-1.735e-09 LVARL=0 LVARW=0 LAP=3.471e-08 WVARO=0 WVARL=0 WVARW=0 WOT=0 DLQ=3.537e-08 DWQ=3e-08 VFBO=-1.0717 VFBL=-0.03 VFBW=0 VFBLW=0 STVFBO=0.00057379 STVFBL=8.6794e-05 STVFBW=4.9309e-05 STVFBLW=-3.6436e-05 ST2VFBO=0 TOXO=6.945e-09 EPSROXO=3.9 NSUBO=4.2268e+23 NSUBW=0.01112 WSEG=5.362e-08 NPCK=8.0711e+23 NPCKW=-0.011403 WSEGP=1e-06 LPCK=8.3733e-09 LPCKW=0.077499 FOL1=0.065253 FOL2=0.010199 FACNEFFACO=1 FACNEFFACL=0 FACNEFFACW=0 FACNEFFACLW=0 GFACNUDO=1 GFACNUDL=0 GFACNUDLEXP=1 GFACNUDW=0 GFACNUDLW=0 VSBNUDO=0 DVSBNUDO=1 VNSUBO=0 NSLPO=0.05 DNSUBO=0.03585 DPHIBO=-0.077884807 DPHIBL=0.00526388544 DPHIBLEXP=2.1893 DPHIBW=-0.011141504 DPHIBLW=-9.3915789e-05 DELVTACO=0 DELVTACL=0 DELVTACLEXP=1 DELVTACW=0 DELVTACLW=0 NPO=1.092e+26 NPL=0.2188 TOXOVO=6.945e-09 TOXOVDO=2e-09 LOV=3.471e-08 LOVD=0 NOVO=1.99e+26 NOVDO=5e+25 CTO=-0.006328 CTL=0 CTLEXP=1 CTW=0.3006 CTLW=-0.01196 CTGO=0 CTBO=0 STCTO=1 CFL=0.00045884 CFLEXP=2.2055 CFW=0.45909 CFBO=1 CFDO=0 PSCEL=0 PSCELEXP=2 PSCEW=0 PSCEBO=0 PSCEDO=0 UO=0.018428 FBET1=0.15952 FBET1W=-2.1872 LP1=9.9822e-08 LP1W=-1.0871 FBET2=-2.7066 LP2=5.8401e-08 BETW1=-0.097534 BETW2=0.022314 WBET=7.9844e-10 STBETO=1.6489 STBETL=0.029528 STBETW=0.037078 STBETLW=0.046991 MUEO=1.7444601 MUEW=-0.06367 STMUEO=1.0816 THEMUO=1.0324 STTHEMUO=0.26337 CSO=0.18648 CSL=0.21903 CSLEXP=2.0917 CSW=0.0072837 CSLW=0.02 STCSO=2 THECSO=2 STTHECSO=0 XCORO=0.001363 XCORL=8 XCORW=0.0060537 XCORLW=0.058951 STXCORO=-6.939e-18 FETAO=1.2853 RSW1=1970 RSW2=-0.057547 STRSO=-0.24812 RSBO=0.074639 RSGO=0.23490984 THESATO=8.4917e-05 THESATL=0.0067396 THESATLEXP=2.395 THESATW=1.1549 THESATLW=-0.01 STTHESATO=3.0405 STTHESATL=-0.16001 STTHESATW=-0.96988 STTHESATLW=0.36213 THESATBO=0.1 THESATGO=0.6304 AXO=16.822 AXL=3.0092 ALPL=0.0058454 ALPLEXP=0.47562 ALPW=-0.065973 ALP1L1=4.4409e-16 ALP1LEXP=1.347 ALP1L2=1 ALP1W=2 ALP2L1=3.6779e-06 ALP2LEXP=0.2531 ALP2L2=2.2204e-15 ALP2W=0.9582 VPO=1.8436e-06 A1O=47.788 A1L=0.029145 A1W=0.01435 A2O=38.581 STA2O=-0.0049931 A3O=1.1753 A3L=-0.069795 A3W=0.0032538 A4O=0.12593 A4L=-0.07 A4W=-0.04811 GCOO=0 IGINVLW=0 IGOVW=0 IGOVDW=0 STIGO=2 GC2O=0.375 GC3O=0.063 CHIBO=3.1 AGIDLW=6e-10 AGIDLDW=0 BGIDLO=5.5970304 BGIDLDO=41 STBGIDLO=-0.0049461 STBGIDLDO=0 CGIDLO=0.23693 CGIDLDO=0 CGBOVL=-4.669e-16 CFRDW=0 FNTO=1 FNTEXCL=0 NFALW=1.3e+25 NFBLW=5289000000 NFCLW=2e-07 EFO=1.152 LINTNOI=2.5e-08 ALPNOI=2 WEDGE=1e-08 WEDGEW=0 VFBEDGEO=-1 STVFBEDGEO=0.0005 STVFBEDGEL=0 STVFBEDGEW=0 STVFBEDGELW=0 DPHIBEDGEO=0 DPHIBEDGEL=0 DPHIBEDGELEXP=1 DPHIBEDGEW=0 DPHIBEDGELW=0 NSUBEDGEO=5e+23 NSUBEDGEL=0 NSUBEDGELEXP=1 NSUBEDGEW=0 NSUBEDGELW=0 CTEDGEO=0 CTEDGEL=0 CTEDGELEXP=1 FBETEDGE=0 LPEDGE=1e-08 BETEDGEW=0 STBETEDGEO=1 STBETEDGEL=0 STBETEDGEW=0 STBETEDGELW=0 PSCEEDGEL=0 PSCEEDGELEXP=2 PSCEEDGEW=0 PSCEBEDGEO=0 PSCEDEDGEO=0 CFEDGEL=0 CFEDGELEXP=2 CFEDGEW=0 CFDEDGEO=0 CFBEDGEO=0 FNTEDGEO=1 NFAEDGELW=8e+22 NFBEDGELW=30000000 NFCEDGELW=0 EFEDGEO=1 SAREF=1e-06 SBREF=1e-06 WLOD=0 KUO=0 KVSAT=0 TKUO=0 LKUO=0 WKUO=0 PKUO=0 LLODKUO=0 WLODKUO=0 KVTHO=0 LKVTHO=0 WKVTHO=0 PKVTHO=0 LLODVTH=0 WLODVTH=0 STETAO=0 LODETAO=1 SCREF=1e-06 WEB=0 WEC=0 KVTHOWEO=0 KVTHOWEL=0 KVTHOWEW=0 KVTHOWELW=0 KUOWEO=0 KUOWEL=0 KUOWEW=0 KUOWELW=0 TRJ=21 SWJUNEXP=0 IMAX=0.0024527 FREV=1000 CJORBOT=0.0008095 CJORSTI=4.2583e-11 CJORGAT=3.1e-11 VBIRBOT=0.72606 VBIRSTI=0.69819 VBIRGAT=1.199 PBOT=0.33078 PSTI=0.22409 PGAT=0.4474 CJORBOTD=0.001 CJORSTID=1e-09 CJORGATD=1e-09 VBIRBOTD=1 VBIRSTID=1 VBIRGATD=1 PBOTD=0.5 PSTID=0.5 PGATD=0.5 PHIGBOT=1.0641 PHIGSTI=1.3946 PHIGGAT=1.83 IDSATRBOT=3.0606e-08 IDSATRSTI=3.6127e-15 IDSATRGAT=0 CSRHBOT=100 CSRHSTI=0.0001 CSRHGAT=0.0001 XJUNSTI=4.93e-08 XJUNGAT=7.062e-07 PHIGBOTD=1.16 PHIGSTID=1.16 PHIGGATD=1.16 IDSATRBOTD=1e-12 IDSATRSTID=1e-18 IDSATRGATD=1e-18 CSRHBOTD=100 CSRHSTID=0.0001 CSRHGATD=0.0001 XJUNSTID=1e-07 XJUNGATD=1e-07 CTATBOT=100 CTATSTI=0.0001 CTATGAT=0.0001 MEFFTATBOT=0.25 MEFFTATSTI=0.25 MEFFTATGAT=0.25 CTATBOTD=100 CTATSTID=0.0001 CTATGATD=0.0001 MEFFTATBOTD=0.25 MEFFTATSTID=0.25 MEFFTATGATD=0.25 CBBTBOT=1e-12 CBBTSTI=1e-21 CBBTGAT=1e-18 FBBTRBOT=1000000000 FBBTRSTI=1000000000 FBBTRGAT=1000000000 STFBBTBOT=-0.001 STFBBTSTI=-0.001 STFBBTGAT=-0.001 CBBTBOTD=1e-12 CBBTSTID=1e-18 CBBTGATD=1e-18 FBBTRBOTD=1000000000 FBBTRSTID=1000000000 FBBTRGATD=1000000000 STFBBTBOTD=-0.001 STFBBTSTID=-0.001 STFBBTGATD=-0.001 VBRBOT=10 VBRSTI=10 VBRGAT=10 PBRBOT=4 PBRSTI=4 PBRGAT=4 VBRBOTD=10 VBRSTID=10 VBRGATD=10 PBRBOTD=4 PBRSTID=4 PBRGATD=4 VJUNREF=2.5 FJUNQ=0.03 VJUNREFD=2.5 FJUNQD=0.03 RINT=0 RVPOLY=0 DLSIL=0 RSH=0 RSHD=0 CFRW=0 RSHG=40 RGO=15 RBULKO=200 RWELLO=100 RJUNSO=200 RJUNDO=200 SWSOA=0 VGS_MAX=3 VGD_MAX=3 VGB_MAX=3 VDS_MAX=3 VDB_MAX=1.6 VSB_MAX=1.6
model hvp_w11367n_l400n_ng2 PSP103VA TYPE=-1 TR=27 DTA=0 SWGEO=1 SWIGATE=1 SWIMPACT=1 SWGIDL=1 SWJUNCAP=3 SWJUNASYM=0 SWNUD=0 SWEDGE=0 SWDELVTAC=0 SWIGN=1 QMC=1 LVARO=-1.735e-09 LVARL=0 LVARW=0 LAP=3.471e-08 WVARO=0 WVARL=0 WVARW=0 WOT=0 DLQ=3.537e-08 DWQ=3e-08 VFBO=-1.0717 VFBL=-0.03 VFBW=0 VFBLW=0 STVFBO=0.00057379 STVFBL=8.6794e-05 STVFBW=4.9309e-05 STVFBLW=-3.6436e-05 ST2VFBO=0 TOXO=6.945e-09 EPSROXO=3.9 NSUBO=4.2268e+23 NSUBW=0.01112 WSEG=5.362e-08 NPCK=8.0711e+23 NPCKW=-0.011403 WSEGP=1e-06 LPCK=8.3733e-09 LPCKW=0.077499 FOL1=0.065253 FOL2=0.010199 FACNEFFACO=1 FACNEFFACL=0 FACNEFFACW=0 FACNEFFACLW=0 GFACNUDO=1 GFACNUDL=0 GFACNUDLEXP=1 GFACNUDW=0 GFACNUDLW=0 VSBNUDO=0 DVSBNUDO=1 VNSUBO=0 NSLPO=0.05 DNSUBO=0.03585 DPHIBO=-0.077884807 DPHIBL=0.00526388544 DPHIBLEXP=2.1893 DPHIBW=-0.011141504 DPHIBLW=-9.3915789e-05 DELVTACO=0 DELVTACL=0 DELVTACLEXP=1 DELVTACW=0 DELVTACLW=0 NPO=1.092e+26 NPL=0.2188 TOXOVO=6.945e-09 TOXOVDO=2e-09 LOV=3.471e-08 LOVD=0 NOVO=1.99e+26 NOVDO=5e+25 CTO=-0.006328 CTL=0 CTLEXP=1 CTW=0.3006 CTLW=-0.01196 CTGO=0 CTBO=0 STCTO=1 CFL=0.00045884 CFLEXP=2.2055 CFW=0.45909 CFBO=1 CFDO=0 PSCEL=0 PSCELEXP=2 PSCEW=0 PSCEBO=0 PSCEDO=0 UO=0.018428 FBET1=0.15952 FBET1W=-2.1872 LP1=9.9822e-08 LP1W=-1.0871 FBET2=-2.7066 LP2=5.8401e-08 BETW1=-0.097534 BETW2=0.022314 WBET=7.9844e-10 STBETO=1.6489 STBETL=0.029528 STBETW=0.037078 STBETLW=0.046991 MUEO=1.7444601 MUEW=-0.06367 STMUEO=1.0816 THEMUO=1.0324 STTHEMUO=0.26337 CSO=0.18648 CSL=0.21903 CSLEXP=2.0917 CSW=0.0072837 CSLW=0.02 STCSO=2 THECSO=2 STTHECSO=0 XCORO=0.001363 XCORL=8 XCORW=0.0060537 XCORLW=0.058951 STXCORO=-6.939e-18 FETAO=1.2853 RSW1=1970 RSW2=-0.057547 STRSO=-0.24812 RSBO=0.074639 RSGO=0.23490984 THESATO=8.4917e-05 THESATL=0.0067396 THESATLEXP=2.395 THESATW=1.1549 THESATLW=-0.01 STTHESATO=3.0405 STTHESATL=-0.16001 STTHESATW=-0.96988 STTHESATLW=0.36213 THESATBO=0.1 THESATGO=0.6304 AXO=16.822 AXL=3.0092 ALPL=0.0058454 ALPLEXP=0.47562 ALPW=-0.065973 ALP1L1=4.4409e-16 ALP1LEXP=1.347 ALP1L2=1 ALP1W=2 ALP2L1=3.6779e-06 ALP2LEXP=0.2531 ALP2L2=2.2204e-15 ALP2W=0.9582 VPO=1.8436e-06 A1O=47.788 A1L=0.029145 A1W=0.01435 A2O=38.581 STA2O=-0.0049931 A3O=1.1753 A3L=-0.069795 A3W=0.0032538 A4O=0.12593 A4L=-0.07 A4W=-0.04811 GCOO=0 IGINVLW=0 IGOVW=0 IGOVDW=0 STIGO=2 GC2O=0.375 GC3O=0.063 CHIBO=3.1 AGIDLW=6e-10 AGIDLDW=0 BGIDLO=5.5970304 BGIDLDO=41 STBGIDLO=-0.0049461 STBGIDLDO=0 CGIDLO=0.23693 CGIDLDO=0 CGBOVL=-4.669e-16 CFRDW=0 FNTO=1 FNTEXCL=0 NFALW=1.3e+25 NFBLW=5289000000 NFCLW=2e-07 EFO=1.152 LINTNOI=2.5e-08 ALPNOI=2 WEDGE=1e-08 WEDGEW=0 VFBEDGEO=-1 STVFBEDGEO=0.0005 STVFBEDGEL=0 STVFBEDGEW=0 STVFBEDGELW=0 DPHIBEDGEO=0 DPHIBEDGEL=0 DPHIBEDGELEXP=1 DPHIBEDGEW=0 DPHIBEDGELW=0 NSUBEDGEO=5e+23 NSUBEDGEL=0 NSUBEDGELEXP=1 NSUBEDGEW=0 NSUBEDGELW=0 CTEDGEO=0 CTEDGEL=0 CTEDGELEXP=1 FBETEDGE=0 LPEDGE=1e-08 BETEDGEW=0 STBETEDGEO=1 STBETEDGEL=0 STBETEDGEW=0 STBETEDGELW=0 PSCEEDGEL=0 PSCEEDGELEXP=2 PSCEEDGEW=0 PSCEBEDGEO=0 PSCEDEDGEO=0 CFEDGEL=0 CFEDGELEXP=2 CFEDGEW=0 CFDEDGEO=0 CFBEDGEO=0 FNTEDGEO=1 NFAEDGELW=8e+22 NFBEDGELW=30000000 NFCEDGELW=0 EFEDGEO=1 SAREF=1e-06 SBREF=1e-06 WLOD=0 KUO=0 KVSAT=0 TKUO=0 LKUO=0 WKUO=0 PKUO=0 LLODKUO=0 WLODKUO=0 KVTHO=0 LKVTHO=0 WKVTHO=0 PKVTHO=0 LLODVTH=0 WLODVTH=0 STETAO=0 LODETAO=1 SCREF=1e-06 WEB=0 WEC=0 KVTHOWEO=0 KVTHOWEL=0 KVTHOWEW=0 KVTHOWELW=0 KUOWEO=0 KUOWEL=0 KUOWEW=0 KUOWELW=0 TRJ=21 SWJUNEXP=0 IMAX=0.0024527 FREV=1000 CJORBOT=0.0008095 CJORSTI=4.2583e-11 CJORGAT=3.1e-11 VBIRBOT=0.72606 VBIRSTI=0.69819 VBIRGAT=1.199 PBOT=0.33078 PSTI=0.22409 PGAT=0.4474 CJORBOTD=0.001 CJORSTID=1e-09 CJORGATD=1e-09 VBIRBOTD=1 VBIRSTID=1 VBIRGATD=1 PBOTD=0.5 PSTID=0.5 PGATD=0.5 PHIGBOT=1.0641 PHIGSTI=1.3946 PHIGGAT=1.83 IDSATRBOT=3.0606e-08 IDSATRSTI=3.6127e-15 IDSATRGAT=0 CSRHBOT=100 CSRHSTI=0.0001 CSRHGAT=0.0001 XJUNSTI=4.93e-08 XJUNGAT=7.062e-07 PHIGBOTD=1.16 PHIGSTID=1.16 PHIGGATD=1.16 IDSATRBOTD=1e-12 IDSATRSTID=1e-18 IDSATRGATD=1e-18 CSRHBOTD=100 CSRHSTID=0.0001 CSRHGATD=0.0001 XJUNSTID=1e-07 XJUNGATD=1e-07 CTATBOT=100 CTATSTI=0.0001 CTATGAT=0.0001 MEFFTATBOT=0.25 MEFFTATSTI=0.25 MEFFTATGAT=0.25 CTATBOTD=100 CTATSTID=0.0001 CTATGATD=0.0001 MEFFTATBOTD=0.25 MEFFTATSTID=0.25 MEFFTATGATD=0.25 CBBTBOT=1e-12 CBBTSTI=1e-21 CBBTGAT=1e-18 FBBTRBOT=1000000000 FBBTRSTI=1000000000 FBBTRGAT=1000000000 STFBBTBOT=-0.001 STFBBTSTI=-0.001 STFBBTGAT=-0.001 CBBTBOTD=1e-12 CBBTSTID=1e-18 CBBTGATD=1e-18 FBBTRBOTD=1000000000 FBBTRSTID=1000000000 FBBTRGATD=1000000000 STFBBTBOTD=-0.001 STFBBTSTID=-0.001 STFBBTGATD=-0.001 VBRBOT=10 VBRSTI=10 VBRGAT=10 PBRBOT=4 PBRSTI=4 PBRGAT=4 VBRBOTD=10 VBRSTID=10 VBRGATD=10 PBRBOTD=4 PBRSTID=4 PBRGATD=4 VJUNREF=2.5 FJUNQ=0.03 VJUNREFD=2.5 FJUNQD=0.03 RINT=0 RVPOLY=0 DLSIL=0 RSH=0 RSHD=0 CFRW=0 RSHG=40 RGO=15 RBULKO=351.8976 RWELLO=175.9488 RJUNSO=175.9488 RJUNDO=175.9488 SWSOA=0 VGS_MAX=3 VGD_MAX=3 VGB_MAX=3 VDS_MAX=3 VDB_MAX=1.6 VSB_MAX=1.6
model hvp_w11509n_l400n_ng2 PSP103VA TYPE=-1 TR=27 DTA=0 SWGEO=1 SWIGATE=1 SWIMPACT=1 SWGIDL=1 SWJUNCAP=3 SWJUNASYM=0 SWNUD=0 SWEDGE=0 SWDELVTAC=0 SWIGN=1 QMC=1 LVARO=-1.735e-09 LVARL=0 LVARW=0 LAP=3.471e-08 WVARO=0 WVARL=0 WVARW=0 WOT=0 DLQ=3.537e-08 DWQ=3e-08 VFBO=-1.0717 VFBL=-0.03 VFBW=0 VFBLW=0 STVFBO=0.00057379 STVFBL=8.6794e-05 STVFBW=4.9309e-05 STVFBLW=-3.6436e-05 ST2VFBO=0 TOXO=6.945e-09 EPSROXO=3.9 NSUBO=4.2268e+23 NSUBW=0.01112 WSEG=5.362e-08 NPCK=8.0711e+23 NPCKW=-0.011403 WSEGP=1e-06 LPCK=8.3733e-09 LPCKW=0.077499 FOL1=0.065253 FOL2=0.010199 FACNEFFACO=1 FACNEFFACL=0 FACNEFFACW=0 FACNEFFACLW=0 GFACNUDO=1 GFACNUDL=0 GFACNUDLEXP=1 GFACNUDW=0 GFACNUDLW=0 VSBNUDO=0 DVSBNUDO=1 VNSUBO=0 NSLPO=0.05 DNSUBO=0.03585 DPHIBO=-0.077884807 DPHIBL=0.00526388544 DPHIBLEXP=2.1893 DPHIBW=-0.011141504 DPHIBLW=-9.3915789e-05 DELVTACO=0 DELVTACL=0 DELVTACLEXP=1 DELVTACW=0 DELVTACLW=0 NPO=1.092e+26 NPL=0.2188 TOXOVO=6.945e-09 TOXOVDO=2e-09 LOV=3.471e-08 LOVD=0 NOVO=1.99e+26 NOVDO=5e+25 CTO=-0.006328 CTL=0 CTLEXP=1 CTW=0.3006 CTLW=-0.01196 CTGO=0 CTBO=0 STCTO=1 CFL=0.00045884 CFLEXP=2.2055 CFW=0.45909 CFBO=1 CFDO=0 PSCEL=0 PSCELEXP=2 PSCEW=0 PSCEBO=0 PSCEDO=0 UO=0.018428 FBET1=0.15952 FBET1W=-2.1872 LP1=9.9822e-08 LP1W=-1.0871 FBET2=-2.7066 LP2=5.8401e-08 BETW1=-0.097534 BETW2=0.022314 WBET=7.9844e-10 STBETO=1.6489 STBETL=0.029528 STBETW=0.037078 STBETLW=0.046991 MUEO=1.7444601 MUEW=-0.06367 STMUEO=1.0816 THEMUO=1.0324 STTHEMUO=0.26337 CSO=0.18648 CSL=0.21903 CSLEXP=2.0917 CSW=0.0072837 CSLW=0.02 STCSO=2 THECSO=2 STTHECSO=0 XCORO=0.001363 XCORL=8 XCORW=0.0060537 XCORLW=0.058951 STXCORO=-6.939e-18 FETAO=1.2853 RSW1=1970 RSW2=-0.057547 STRSO=-0.24812 RSBO=0.074639 RSGO=0.23490984 THESATO=8.4917e-05 THESATL=0.0067396 THESATLEXP=2.395 THESATW=1.1549 THESATLW=-0.01 STTHESATO=3.0405 STTHESATL=-0.16001 STTHESATW=-0.96988 STTHESATLW=0.36213 THESATBO=0.1 THESATGO=0.6304 AXO=16.822 AXL=3.0092 ALPL=0.0058454 ALPLEXP=0.47562 ALPW=-0.065973 ALP1L1=4.4409e-16 ALP1LEXP=1.347 ALP1L2=1 ALP1W=2 ALP2L1=3.6779e-06 ALP2LEXP=0.2531 ALP2L2=2.2204e-15 ALP2W=0.9582 VPO=1.8436e-06 A1O=47.788 A1L=0.029145 A1W=0.01435 A2O=38.581 STA2O=-0.0049931 A3O=1.1753 A3L=-0.069795 A3W=0.0032538 A4O=0.12593 A4L=-0.07 A4W=-0.04811 GCOO=0 IGINVLW=0 IGOVW=0 IGOVDW=0 STIGO=2 GC2O=0.375 GC3O=0.063 CHIBO=3.1 AGIDLW=6e-10 AGIDLDW=0 BGIDLO=5.5970304 BGIDLDO=41 STBGIDLO=-0.0049461 STBGIDLDO=0 CGIDLO=0.23693 CGIDLDO=0 CGBOVL=-4.669e-16 CFRDW=0 FNTO=1 FNTEXCL=0 NFALW=1.3e+25 NFBLW=5289000000 NFCLW=2e-07 EFO=1.152 LINTNOI=2.5e-08 ALPNOI=2 WEDGE=1e-08 WEDGEW=0 VFBEDGEO=-1 STVFBEDGEO=0.0005 STVFBEDGEL=0 STVFBEDGEW=0 STVFBEDGELW=0 DPHIBEDGEO=0 DPHIBEDGEL=0 DPHIBEDGELEXP=1 DPHIBEDGEW=0 DPHIBEDGELW=0 NSUBEDGEO=5e+23 NSUBEDGEL=0 NSUBEDGELEXP=1 NSUBEDGEW=0 NSUBEDGELW=0 CTEDGEO=0 CTEDGEL=0 CTEDGELEXP=1 FBETEDGE=0 LPEDGE=1e-08 BETEDGEW=0 STBETEDGEO=1 STBETEDGEL=0 STBETEDGEW=0 STBETEDGELW=0 PSCEEDGEL=0 PSCEEDGELEXP=2 PSCEEDGEW=0 PSCEBEDGEO=0 PSCEDEDGEO=0 CFEDGEL=0 CFEDGELEXP=2 CFEDGEW=0 CFDEDGEO=0 CFBEDGEO=0 FNTEDGEO=1 NFAEDGELW=8e+22 NFBEDGELW=30000000 NFCEDGELW=0 EFEDGEO=1 SAREF=1e-06 SBREF=1e-06 WLOD=0 KUO=0 KVSAT=0 TKUO=0 LKUO=0 WKUO=0 PKUO=0 LLODKUO=0 WLODKUO=0 KVTHO=0 LKVTHO=0 WKVTHO=0 PKVTHO=0 LLODVTH=0 WLODVTH=0 STETAO=0 LODETAO=1 SCREF=1e-06 WEB=0 WEC=0 KVTHOWEO=0 KVTHOWEL=0 KVTHOWEW=0 KVTHOWELW=0 KUOWEO=0 KUOWEL=0 KUOWEW=0 KUOWELW=0 TRJ=21 SWJUNEXP=0 IMAX=0.0024527 FREV=1000 CJORBOT=0.0008095 CJORSTI=4.2583e-11 CJORGAT=3.1e-11 VBIRBOT=0.72606 VBIRSTI=0.69819 VBIRGAT=1.199 PBOT=0.33078 PSTI=0.22409 PGAT=0.4474 CJORBOTD=0.001 CJORSTID=1e-09 CJORGATD=1e-09 VBIRBOTD=1 VBIRSTID=1 VBIRGATD=1 PBOTD=0.5 PSTID=0.5 PGATD=0.5 PHIGBOT=1.0641 PHIGSTI=1.3946 PHIGGAT=1.83 IDSATRBOT=3.0606e-08 IDSATRSTI=3.6127e-15 IDSATRGAT=0 CSRHBOT=100 CSRHSTI=0.0001 CSRHGAT=0.0001 XJUNSTI=4.93e-08 XJUNGAT=7.062e-07 PHIGBOTD=1.16 PHIGSTID=1.16 PHIGGATD=1.16 IDSATRBOTD=1e-12 IDSATRSTID=1e-18 IDSATRGATD=1e-18 CSRHBOTD=100 CSRHSTID=0.0001 CSRHGATD=0.0001 XJUNSTID=1e-07 XJUNGATD=1e-07 CTATBOT=100 CTATSTI=0.0001 CTATGAT=0.0001 MEFFTATBOT=0.25 MEFFTATSTI=0.25 MEFFTATGAT=0.25 CTATBOTD=100 CTATSTID=0.0001 CTATGATD=0.0001 MEFFTATBOTD=0.25 MEFFTATSTID=0.25 MEFFTATGATD=0.25 CBBTBOT=1e-12 CBBTSTI=1e-21 CBBTGAT=1e-18 FBBTRBOT=1000000000 FBBTRSTI=1000000000 FBBTRGAT=1000000000 STFBBTBOT=-0.001 STFBBTSTI=-0.001 STFBBTGAT=-0.001 CBBTBOTD=1e-12 CBBTSTID=1e-18 CBBTGATD=1e-18 FBBTRBOTD=1000000000 FBBTRSTID=1000000000 FBBTRGATD=1000000000 STFBBTBOTD=-0.001 STFBBTSTID=-0.001 STFBBTGATD=-0.001 VBRBOT=10 VBRSTI=10 VBRGAT=10 PBRBOT=4 PBRSTI=4 PBRGAT=4 VBRBOTD=10 VBRSTID=10 VBRGATD=10 PBRBOTD=4 PBRSTID=4 PBRGATD=4 VJUNREF=2.5 FJUNQ=0.03 VJUNREFD=2.5 FJUNQD=0.03 RINT=0 RVPOLY=0 DLSIL=0 RSH=0 RSHD=0 CFRW=0 RSHG=40 RGO=15 RBULKO=347.5531852 RWELLO=173.7765926 RJUNSO=173.7765926 RJUNDO=173.7765926 SWSOA=0 VGS_MAX=3 VGD_MAX=3 VGB_MAX=3 VDS_MAX=3 VDB_MAX=1.6 VSB_MAX=1.6
model hvp_w2000n_l400n_ng1 PSP103VA TYPE=-1 TR=27 DTA=0 SWGEO=1 SWIGATE=1 SWIMPACT=1 SWGIDL=1 SWJUNCAP=3 SWJUNASYM=0 SWNUD=0 SWEDGE=0 SWDELVTAC=0 SWIGN=1 QMC=1 LVARO=-1.735e-09 LVARL=0 LVARW=0 LAP=3.471e-08 WVARO=0 WVARL=0 WVARW=0 WOT=0 DLQ=3.537e-08 DWQ=3e-08 VFBO=-1.0717 VFBL=-0.03 VFBW=0 VFBLW=0 STVFBO=0.00057379 STVFBL=8.6794e-05 STVFBW=4.9309e-05 STVFBLW=-3.6436e-05 ST2VFBO=0 TOXO=6.945e-09 EPSROXO=3.9 NSUBO=4.2268e+23 NSUBW=0.01112 WSEG=5.362e-08 NPCK=8.0711e+23 NPCKW=-0.011403 WSEGP=1e-06 LPCK=8.3733e-09 LPCKW=0.077499 FOL1=0.065253 FOL2=0.010199 FACNEFFACO=1 FACNEFFACL=0 FACNEFFACW=0 FACNEFFACLW=0 GFACNUDO=1 GFACNUDL=0 GFACNUDLEXP=1 GFACNUDW=0 GFACNUDLW=0 VSBNUDO=0 DVSBNUDO=1 VNSUBO=0 NSLPO=0.05 DNSUBO=0.03585 DPHIBO=-0.077884807 DPHIBL=0.00526388544 DPHIBLEXP=2.1893 DPHIBW=-0.011141504 DPHIBLW=-9.3915789e-05 DELVTACO=0 DELVTACL=0 DELVTACLEXP=1 DELVTACW=0 DELVTACLW=0 NPO=1.092e+26 NPL=0.2188 TOXOVO=6.945e-09 TOXOVDO=2e-09 LOV=3.471e-08 LOVD=0 NOVO=1.99e+26 NOVDO=5e+25 CTO=-0.006328 CTL=0 CTLEXP=1 CTW=0.3006 CTLW=-0.01196 CTGO=0 CTBO=0 STCTO=1 CFL=0.00045884 CFLEXP=2.2055 CFW=0.45909 CFBO=1 CFDO=0 PSCEL=0 PSCELEXP=2 PSCEW=0 PSCEBO=0 PSCEDO=0 UO=0.018428 FBET1=0.15952 FBET1W=-2.1872 LP1=9.9822e-08 LP1W=-1.0871 FBET2=-2.7066 LP2=5.8401e-08 BETW1=-0.097534 BETW2=0.022314 WBET=7.9844e-10 STBETO=1.6489 STBETL=0.029528 STBETW=0.037078 STBETLW=0.046991 MUEO=1.7444601 MUEW=-0.06367 STMUEO=1.0816 THEMUO=1.0324 STTHEMUO=0.26337 CSO=0.18648 CSL=0.21903 CSLEXP=2.0917 CSW=0.0072837 CSLW=0.02 STCSO=2 THECSO=2 STTHECSO=0 XCORO=0.001363 XCORL=8 XCORW=0.0060537 XCORLW=0.058951 STXCORO=-6.939e-18 FETAO=1.2853 RSW1=1970 RSW2=-0.057547 STRSO=-0.24812 RSBO=0.074639 RSGO=0.23490984 THESATO=8.4917e-05 THESATL=0.0067396 THESATLEXP=2.395 THESATW=1.1549 THESATLW=-0.01 STTHESATO=3.0405 STTHESATL=-0.16001 STTHESATW=-0.96988 STTHESATLW=0.36213 THESATBO=0.1 THESATGO=0.6304 AXO=16.822 AXL=3.0092 ALPL=0.0058454 ALPLEXP=0.47562 ALPW=-0.065973 ALP1L1=4.4409e-16 ALP1LEXP=1.347 ALP1L2=1 ALP1W=2 ALP2L1=3.6779e-06 ALP2LEXP=0.2531 ALP2L2=2.2204e-15 ALP2W=0.9582 VPO=1.8436e-06 A1O=47.788 A1L=0.029145 A1W=0.01435 A2O=38.581 STA2O=-0.0049931 A3O=1.1753 A3L=-0.069795 A3W=0.0032538 A4O=0.12593 A4L=-0.07 A4W=-0.04811 GCOO=0 IGINVLW=0 IGOVW=0 IGOVDW=0 STIGO=2 GC2O=0.375 GC3O=0.063 CHIBO=3.1 AGIDLW=6e-10 AGIDLDW=0 BGIDLO=5.5970304 BGIDLDO=41 STBGIDLO=-0.0049461 STBGIDLDO=0 CGIDLO=0.23693 CGIDLDO=0 CGBOVL=-4.669e-16 CFRDW=0 FNTO=1 FNTEXCL=0 NFALW=1.3e+25 NFBLW=5289000000 NFCLW=2e-07 EFO=1.152 LINTNOI=2.5e-08 ALPNOI=2 WEDGE=1e-08 WEDGEW=0 VFBEDGEO=-1 STVFBEDGEO=0.0005 STVFBEDGEL=0 STVFBEDGEW=0 STVFBEDGELW=0 DPHIBEDGEO=0 DPHIBEDGEL=0 DPHIBEDGELEXP=1 DPHIBEDGEW=0 DPHIBEDGELW=0 NSUBEDGEO=5e+23 NSUBEDGEL=0 NSUBEDGELEXP=1 NSUBEDGEW=0 NSUBEDGELW=0 CTEDGEO=0 CTEDGEL=0 CTEDGELEXP=1 FBETEDGE=0 LPEDGE=1e-08 BETEDGEW=0 STBETEDGEO=1 STBETEDGEL=0 STBETEDGEW=0 STBETEDGELW=0 PSCEEDGEL=0 PSCEEDGELEXP=2 PSCEEDGEW=0 PSCEBEDGEO=0 PSCEDEDGEO=0 CFEDGEL=0 CFEDGELEXP=2 CFEDGEW=0 CFDEDGEO=0 CFBEDGEO=0 FNTEDGEO=1 NFAEDGELW=8e+22 NFBEDGELW=30000000 NFCEDGELW=0 EFEDGEO=1 SAREF=1e-06 SBREF=1e-06 WLOD=0 KUO=0 KVSAT=0 TKUO=0 LKUO=0 WKUO=0 PKUO=0 LLODKUO=0 WLODKUO=0 KVTHO=0 LKVTHO=0 WKVTHO=0 PKVTHO=0 LLODVTH=0 WLODVTH=0 STETAO=0 LODETAO=1 SCREF=1e-06 WEB=0 WEC=0 KVTHOWEO=0 KVTHOWEL=0 KVTHOWEW=0 KVTHOWELW=0 KUOWEO=0 KUOWEL=0 KUOWEW=0 KUOWELW=0 TRJ=21 SWJUNEXP=0 IMAX=0.0024527 FREV=1000 CJORBOT=0.0008095 CJORSTI=4.2583e-11 CJORGAT=3.1e-11 VBIRBOT=0.72606 VBIRSTI=0.69819 VBIRGAT=1.199 PBOT=0.33078 PSTI=0.22409 PGAT=0.4474 CJORBOTD=0.001 CJORSTID=1e-09 CJORGATD=1e-09 VBIRBOTD=1 VBIRSTID=1 VBIRGATD=1 PBOTD=0.5 PSTID=0.5 PGATD=0.5 PHIGBOT=1.0641 PHIGSTI=1.3946 PHIGGAT=1.83 IDSATRBOT=3.0606e-08 IDSATRSTI=3.6127e-15 IDSATRGAT=0 CSRHBOT=100 CSRHSTI=0.0001 CSRHGAT=0.0001 XJUNSTI=4.93e-08 XJUNGAT=7.062e-07 PHIGBOTD=1.16 PHIGSTID=1.16 PHIGGATD=1.16 IDSATRBOTD=1e-12 IDSATRSTID=1e-18 IDSATRGATD=1e-18 CSRHBOTD=100 CSRHSTID=0.0001 CSRHGATD=0.0001 XJUNSTID=1e-07 XJUNGATD=1e-07 CTATBOT=100 CTATSTI=0.0001 CTATGAT=0.0001 MEFFTATBOT=0.25 MEFFTATSTI=0.25 MEFFTATGAT=0.25 CTATBOTD=100 CTATSTID=0.0001 CTATGATD=0.0001 MEFFTATBOTD=0.25 MEFFTATSTID=0.25 MEFFTATGATD=0.25 CBBTBOT=1e-12 CBBTSTI=1e-21 CBBTGAT=1e-18 FBBTRBOT=1000000000 FBBTRSTI=1000000000 FBBTRGAT=1000000000 STFBBTBOT=-0.001 STFBBTSTI=-0.001 STFBBTGAT=-0.001 CBBTBOTD=1e-12 CBBTSTID=1e-18 CBBTGATD=1e-18 FBBTRBOTD=1000000000 FBBTRSTID=1000000000 FBBTRGATD=1000000000 STFBBTBOTD=-0.001 STFBBTSTID=-0.001 STFBBTGATD=-0.001 VBRBOT=10 VBRSTI=10 VBRGAT=10 PBRBOT=4 PBRSTI=4 PBRGAT=4 VBRBOTD=10 VBRSTID=10 VBRGATD=10 PBRBOTD=4 PBRSTID=4 PBRGATD=4 VJUNREF=2.5 FJUNQ=0.03 VJUNREFD=2.5 FJUNQD=0.03 RINT=0 RVPOLY=0 DLSIL=0 RSH=0 RSHD=0 CFRW=0 RSHG=40 RGO=15 RBULKO=1000 RWELLO=500 RJUNSO=1000 RJUNDO=1000 SWSOA=0 VGS_MAX=3 VGD_MAX=3 VGB_MAX=3 VDS_MAX=3 VDB_MAX=1.6 VSB_MAX=1.6
model hvp_w2000n_l500n_ng1 PSP103VA TYPE=-1 TR=27 DTA=0 SWGEO=1 SWIGATE=1 SWIMPACT=1 SWGIDL=1 SWJUNCAP=3 SWJUNASYM=0 SWNUD=0 SWEDGE=0 SWDELVTAC=0 SWIGN=1 QMC=1 LVARO=-1.735e-09 LVARL=0 LVARW=0 LAP=3.471e-08 WVARO=0 WVARL=0 WVARW=0 WOT=0 DLQ=3.537e-08 DWQ=3e-08 VFBO=-1.0717 VFBL=-0.03 VFBW=0 VFBLW=0 STVFBO=0.00057379 STVFBL=8.6794e-05 STVFBW=4.9309e-05 STVFBLW=-3.6436e-05 ST2VFBO=0 TOXO=6.945e-09 EPSROXO=3.9 NSUBO=4.2268e+23 NSUBW=0.01112 WSEG=5.362e-08 NPCK=8.0711e+23 NPCKW=-0.011403 WSEGP=1e-06 LPCK=8.3733e-09 LPCKW=0.077499 FOL1=0.065253 FOL2=0.010199 FACNEFFACO=1 FACNEFFACL=0 FACNEFFACW=0 FACNEFFACLW=0 GFACNUDO=1 GFACNUDL=0 GFACNUDLEXP=1 GFACNUDW=0 GFACNUDLW=0 VSBNUDO=0 DVSBNUDO=1 VNSUBO=0 NSLPO=0.05 DNSUBO=0.03585 DPHIBO=-0.077884807 DPHIBL=0.00526388544 DPHIBLEXP=2.1893 DPHIBW=-0.011141504 DPHIBLW=-9.3915789e-05 DELVTACO=0 DELVTACL=0 DELVTACLEXP=1 DELVTACW=0 DELVTACLW=0 NPO=1.092e+26 NPL=0.2188 TOXOVO=6.945e-09 TOXOVDO=2e-09 LOV=3.471e-08 LOVD=0 NOVO=1.99e+26 NOVDO=5e+25 CTO=-0.006328 CTL=0 CTLEXP=1 CTW=0.3006 CTLW=-0.01196 CTGO=0 CTBO=0 STCTO=1 CFL=0.00045884 CFLEXP=2.2055 CFW=0.45909 CFBO=1 CFDO=0 PSCEL=0 PSCELEXP=2 PSCEW=0 PSCEBO=0 PSCEDO=0 UO=0.018428 FBET1=0.15952 FBET1W=-2.1872 LP1=9.9822e-08 LP1W=-1.0871 FBET2=-2.7066 LP2=5.8401e-08 BETW1=-0.097534 BETW2=0.022314 WBET=7.9844e-10 STBETO=1.6489 STBETL=0.029528 STBETW=0.037078 STBETLW=0.046991 MUEO=1.7444601 MUEW=-0.06367 STMUEO=1.0816 THEMUO=1.0324 STTHEMUO=0.26337 CSO=0.18648 CSL=0.21903 CSLEXP=2.0917 CSW=0.0072837 CSLW=0.02 STCSO=2 THECSO=2 STTHECSO=0 XCORO=0.001363 XCORL=8 XCORW=0.0060537 XCORLW=0.058951 STXCORO=-6.939e-18 FETAO=1.2853 RSW1=1970 RSW2=-0.057547 STRSO=-0.24812 RSBO=0.074639 RSGO=0.23490984 THESATO=8.4917e-05 THESATL=0.0067396 THESATLEXP=2.395 THESATW=1.1549 THESATLW=-0.01 STTHESATO=3.0405 STTHESATL=-0.16001 STTHESATW=-0.96988 STTHESATLW=0.36213 THESATBO=0.1 THESATGO=0.6304 AXO=16.822 AXL=3.0092 ALPL=0.0058454 ALPLEXP=0.47562 ALPW=-0.065973 ALP1L1=4.4409e-16 ALP1LEXP=1.347 ALP1L2=1 ALP1W=2 ALP2L1=3.6779e-06 ALP2LEXP=0.2531 ALP2L2=2.2204e-15 ALP2W=0.9582 VPO=1.8436e-06 A1O=47.788 A1L=0.029145 A1W=0.01435 A2O=38.581 STA2O=-0.0049931 A3O=1.1753 A3L=-0.069795 A3W=0.0032538 A4O=0.12593 A4L=-0.07 A4W=-0.04811 GCOO=0 IGINVLW=0 IGOVW=0 IGOVDW=0 STIGO=2 GC2O=0.375 GC3O=0.063 CHIBO=3.1 AGIDLW=6e-10 AGIDLDW=0 BGIDLO=5.5970304 BGIDLDO=41 STBGIDLO=-0.0049461 STBGIDLDO=0 CGIDLO=0.23693 CGIDLDO=0 CGBOVL=-4.669e-16 CFRDW=0 FNTO=1 FNTEXCL=0 NFALW=1.3e+25 NFBLW=5289000000 NFCLW=2e-07 EFO=1.152 LINTNOI=2.5e-08 ALPNOI=2 WEDGE=1e-08 WEDGEW=0 VFBEDGEO=-1 STVFBEDGEO=0.0005 STVFBEDGEL=0 STVFBEDGEW=0 STVFBEDGELW=0 DPHIBEDGEO=0 DPHIBEDGEL=0 DPHIBEDGELEXP=1 DPHIBEDGEW=0 DPHIBEDGELW=0 NSUBEDGEO=5e+23 NSUBEDGEL=0 NSUBEDGELEXP=1 NSUBEDGEW=0 NSUBEDGELW=0 CTEDGEO=0 CTEDGEL=0 CTEDGELEXP=1 FBETEDGE=0 LPEDGE=1e-08 BETEDGEW=0 STBETEDGEO=1 STBETEDGEL=0 STBETEDGEW=0 STBETEDGELW=0 PSCEEDGEL=0 PSCEEDGELEXP=2 PSCEEDGEW=0 PSCEBEDGEO=0 PSCEDEDGEO=0 CFEDGEL=0 CFEDGELEXP=2 CFEDGEW=0 CFDEDGEO=0 CFBEDGEO=0 FNTEDGEO=1 NFAEDGELW=8e+22 NFBEDGELW=30000000 NFCEDGELW=0 EFEDGEO=1 SAREF=1e-06 SBREF=1e-06 WLOD=0 KUO=0 KVSAT=0 TKUO=0 LKUO=0 WKUO=0 PKUO=0 LLODKUO=0 WLODKUO=0 KVTHO=0 LKVTHO=0 WKVTHO=0 PKVTHO=0 LLODVTH=0 WLODVTH=0 STETAO=0 LODETAO=1 SCREF=1e-06 WEB=0 WEC=0 KVTHOWEO=0 KVTHOWEL=0 KVTHOWEW=0 KVTHOWELW=0 KUOWEO=0 KUOWEL=0 KUOWEW=0 KUOWELW=0 TRJ=21 SWJUNEXP=0 IMAX=0.0024527 FREV=1000 CJORBOT=0.0008095 CJORSTI=4.2583e-11 CJORGAT=3.1e-11 VBIRBOT=0.72606 VBIRSTI=0.69819 VBIRGAT=1.199 PBOT=0.33078 PSTI=0.22409 PGAT=0.4474 CJORBOTD=0.001 CJORSTID=1e-09 CJORGATD=1e-09 VBIRBOTD=1 VBIRSTID=1 VBIRGATD=1 PBOTD=0.5 PSTID=0.5 PGATD=0.5 PHIGBOT=1.0641 PHIGSTI=1.3946 PHIGGAT=1.83 IDSATRBOT=3.0606e-08 IDSATRSTI=3.6127e-15 IDSATRGAT=0 CSRHBOT=100 CSRHSTI=0.0001 CSRHGAT=0.0001 XJUNSTI=4.93e-08 XJUNGAT=7.062e-07 PHIGBOTD=1.16 PHIGSTID=1.16 PHIGGATD=1.16 IDSATRBOTD=1e-12 IDSATRSTID=1e-18 IDSATRGATD=1e-18 CSRHBOTD=100 CSRHSTID=0.0001 CSRHGATD=0.0001 XJUNSTID=1e-07 XJUNGATD=1e-07 CTATBOT=100 CTATSTI=0.0001 CTATGAT=0.0001 MEFFTATBOT=0.25 MEFFTATSTI=0.25 MEFFTATGAT=0.25 CTATBOTD=100 CTATSTID=0.0001 CTATGATD=0.0001 MEFFTATBOTD=0.25 MEFFTATSTID=0.25 MEFFTATGATD=0.25 CBBTBOT=1e-12 CBBTSTI=1e-21 CBBTGAT=1e-18 FBBTRBOT=1000000000 FBBTRSTI=1000000000 FBBTRGAT=1000000000 STFBBTBOT=-0.001 STFBBTSTI=-0.001 STFBBTGAT=-0.001 CBBTBOTD=1e-12 CBBTSTID=1e-18 CBBTGATD=1e-18 FBBTRBOTD=1000000000 FBBTRSTID=1000000000 FBBTRGATD=1000000000 STFBBTBOTD=-0.001 STFBBTSTID=-0.001 STFBBTGATD=-0.001 VBRBOT=10 VBRSTI=10 VBRGAT=10 PBRBOT=4 PBRSTI=4 PBRGAT=4 VBRBOTD=10 VBRSTID=10 VBRGATD=10 PBRBOTD=4 PBRSTID=4 PBRGATD=4 VJUNREF=2.5 FJUNQ=0.03 VJUNREFD=2.5 FJUNQD=0.03 RINT=0 RVPOLY=0 DLSIL=0 RSH=0 RSHD=0 CFRW=0 RSHG=40 RGO=15 RBULKO=1000 RWELLO=500 RJUNSO=1250 RJUNDO=1250 SWSOA=0 VGS_MAX=3 VGD_MAX=3 VGB_MAX=3 VDS_MAX=3 VDB_MAX=1.6 VSB_MAX=1.6
model hvp_w20676n_l2000n_ng3 PSP103VA TYPE=-1 TR=27 DTA=0 SWGEO=1 SWIGATE=1 SWIMPACT=1 SWGIDL=1 SWJUNCAP=3 SWJUNASYM=0 SWNUD=0 SWEDGE=0 SWDELVTAC=0 SWIGN=1 QMC=1 LVARO=-1.735e-09 LVARL=0 LVARW=0 LAP=3.471e-08 WVARO=0 WVARL=0 WVARW=0 WOT=0 DLQ=3.537e-08 DWQ=3e-08 VFBO=-1.0717 VFBL=-0.03 VFBW=0 VFBLW=0 STVFBO=0.00057379 STVFBL=8.6794e-05 STVFBW=4.9309e-05 STVFBLW=-3.6436e-05 ST2VFBO=0 TOXO=6.945e-09 EPSROXO=3.9 NSUBO=4.2268e+23 NSUBW=0.01112 WSEG=5.362e-08 NPCK=8.0711e+23 NPCKW=-0.011403 WSEGP=1e-06 LPCK=8.3733e-09 LPCKW=0.077499 FOL1=0.065253 FOL2=0.010199 FACNEFFACO=1 FACNEFFACL=0 FACNEFFACW=0 FACNEFFACLW=0 GFACNUDO=1 GFACNUDL=0 GFACNUDLEXP=1 GFACNUDW=0 GFACNUDLW=0 VSBNUDO=0 DVSBNUDO=1 VNSUBO=0 NSLPO=0.05 DNSUBO=0.03585 DPHIBO=-0.077884807 DPHIBL=0.00526388544 DPHIBLEXP=2.1893 DPHIBW=-0.011141504 DPHIBLW=-9.3915789e-05 DELVTACO=0 DELVTACL=0 DELVTACLEXP=1 DELVTACW=0 DELVTACLW=0 NPO=1.092e+26 NPL=0.2188 TOXOVO=6.945e-09 TOXOVDO=2e-09 LOV=3.471e-08 LOVD=0 NOVO=1.99e+26 NOVDO=5e+25 CTO=-0.006328 CTL=0 CTLEXP=1 CTW=0.3006 CTLW=-0.01196 CTGO=0 CTBO=0 STCTO=1 CFL=0.00045884 CFLEXP=2.2055 CFW=0.45909 CFBO=1 CFDO=0 PSCEL=0 PSCELEXP=2 PSCEW=0 PSCEBO=0 PSCEDO=0 UO=0.018428 FBET1=0.15952 FBET1W=-2.1872 LP1=9.9822e-08 LP1W=-1.0871 FBET2=-2.7066 LP2=5.8401e-08 BETW1=-0.097534 BETW2=0.022314 WBET=7.9844e-10 STBETO=1.6489 STBETL=0.029528 STBETW=0.037078 STBETLW=0.046991 MUEO=1.7444601 MUEW=-0.06367 STMUEO=1.0816 THEMUO=1.0324 STTHEMUO=0.26337 CSO=0.18648 CSL=0.21903 CSLEXP=2.0917 CSW=0.0072837 CSLW=0.02 STCSO=2 THECSO=2 STTHECSO=0 XCORO=0.001363 XCORL=8 XCORW=0.0060537 XCORLW=0.058951 STXCORO=-6.939e-18 FETAO=1.2853 RSW1=1970 RSW2=-0.057547 STRSO=-0.24812 RSBO=0.074639 RSGO=0.23490984 THESATO=8.4917e-05 THESATL=0.0067396 THESATLEXP=2.395 THESATW=1.1549 THESATLW=-0.01 STTHESATO=3.0405 STTHESATL=-0.16001 STTHESATW=-0.96988 STTHESATLW=0.36213 THESATBO=0.1 THESATGO=0.6304 AXO=16.822 AXL=3.0092 ALPL=0.0058454 ALPLEXP=0.47562 ALPW=-0.065973 ALP1L1=4.4409e-16 ALP1LEXP=1.347 ALP1L2=1 ALP1W=2 ALP2L1=3.6779e-06 ALP2LEXP=0.2531 ALP2L2=2.2204e-15 ALP2W=0.9582 VPO=1.8436e-06 A1O=47.788 A1L=0.029145 A1W=0.01435 A2O=38.581 STA2O=-0.0049931 A3O=1.1753 A3L=-0.069795 A3W=0.0032538 A4O=0.12593 A4L=-0.07 A4W=-0.04811 GCOO=0 IGINVLW=0 IGOVW=0 IGOVDW=0 STIGO=2 GC2O=0.375 GC3O=0.063 CHIBO=3.1 AGIDLW=6e-10 AGIDLDW=0 BGIDLO=5.5970304 BGIDLDO=41 STBGIDLO=-0.0049461 STBGIDLDO=0 CGIDLO=0.23693 CGIDLDO=0 CGBOVL=-4.669e-16 CFRDW=0 FNTO=1 FNTEXCL=0 NFALW=1.3e+25 NFBLW=5289000000 NFCLW=2e-07 EFO=1.152 LINTNOI=2.5e-08 ALPNOI=2 WEDGE=1e-08 WEDGEW=0 VFBEDGEO=-1 STVFBEDGEO=0.0005 STVFBEDGEL=0 STVFBEDGEW=0 STVFBEDGELW=0 DPHIBEDGEO=0 DPHIBEDGEL=0 DPHIBEDGELEXP=1 DPHIBEDGEW=0 DPHIBEDGELW=0 NSUBEDGEO=5e+23 NSUBEDGEL=0 NSUBEDGELEXP=1 NSUBEDGEW=0 NSUBEDGELW=0 CTEDGEO=0 CTEDGEL=0 CTEDGELEXP=1 FBETEDGE=0 LPEDGE=1e-08 BETEDGEW=0 STBETEDGEO=1 STBETEDGEL=0 STBETEDGEW=0 STBETEDGELW=0 PSCEEDGEL=0 PSCEEDGELEXP=2 PSCEEDGEW=0 PSCEBEDGEO=0 PSCEDEDGEO=0 CFEDGEL=0 CFEDGELEXP=2 CFEDGEW=0 CFDEDGEO=0 CFBEDGEO=0 FNTEDGEO=1 NFAEDGELW=8e+22 NFBEDGELW=30000000 NFCEDGELW=0 EFEDGEO=1 SAREF=1e-06 SBREF=1e-06 WLOD=0 KUO=0 KVSAT=0 TKUO=0 LKUO=0 WKUO=0 PKUO=0 LLODKUO=0 WLODKUO=0 KVTHO=0 LKVTHO=0 WKVTHO=0 PKVTHO=0 LLODVTH=0 WLODVTH=0 STETAO=0 LODETAO=1 SCREF=1e-06 WEB=0 WEC=0 KVTHOWEO=0 KVTHOWEL=0 KVTHOWEW=0 KVTHOWELW=0 KUOWEO=0 KUOWEL=0 KUOWEW=0 KUOWELW=0 TRJ=21 SWJUNEXP=0 IMAX=0.0024527 FREV=1000 CJORBOT=0.0008095 CJORSTI=4.2583e-11 CJORGAT=3.1e-11 VBIRBOT=0.72606 VBIRSTI=0.69819 VBIRGAT=1.199 PBOT=0.33078 PSTI=0.22409 PGAT=0.4474 CJORBOTD=0.001 CJORSTID=1e-09 CJORGATD=1e-09 VBIRBOTD=1 VBIRSTID=1 VBIRGATD=1 PBOTD=0.5 PSTID=0.5 PGATD=0.5 PHIGBOT=1.0641 PHIGSTI=1.3946 PHIGGAT=1.83 IDSATRBOT=3.0606e-08 IDSATRSTI=3.6127e-15 IDSATRGAT=0 CSRHBOT=100 CSRHSTI=0.0001 CSRHGAT=0.0001 XJUNSTI=4.93e-08 XJUNGAT=7.062e-07 PHIGBOTD=1.16 PHIGSTID=1.16 PHIGGATD=1.16 IDSATRBOTD=1e-12 IDSATRSTID=1e-18 IDSATRGATD=1e-18 CSRHBOTD=100 CSRHSTID=0.0001 CSRHGATD=0.0001 XJUNSTID=1e-07 XJUNGATD=1e-07 CTATBOT=100 CTATSTI=0.0001 CTATGAT=0.0001 MEFFTATBOT=0.25 MEFFTATSTI=0.25 MEFFTATGAT=0.25 CTATBOTD=100 CTATSTID=0.0001 CTATGATD=0.0001 MEFFTATBOTD=0.25 MEFFTATSTID=0.25 MEFFTATGATD=0.25 CBBTBOT=1e-12 CBBTSTI=1e-21 CBBTGAT=1e-18 FBBTRBOT=1000000000 FBBTRSTI=1000000000 FBBTRGAT=1000000000 STFBBTBOT=-0.001 STFBBTSTI=-0.001 STFBBTGAT=-0.001 CBBTBOTD=1e-12 CBBTSTID=1e-18 CBBTGATD=1e-18 FBBTRBOTD=1000000000 FBBTRSTID=1000000000 FBBTRGATD=1000000000 STFBBTBOTD=-0.001 STFBBTSTID=-0.001 STFBBTGATD=-0.001 VBRBOT=10 VBRSTI=10 VBRGAT=10 PBRBOT=4 PBRSTI=4 PBRGAT=4 VBRBOTD=10 VBRSTID=10 VBRGATD=10 PBRBOTD=4 PBRSTID=4 PBRGATD=4 VJUNREF=2.5 FJUNQ=0.03 VJUNREFD=2.5 FJUNQD=0.03 RINT=0 RVPOLY=0 DLSIL=0 RSH=0 RSHD=0 CFRW=0 RSHG=40 RGO=15 RBULKO=290.1922685 RWELLO=145.0961342 RJUNSO=483.6537808 RJUNDO=483.6537808 SWSOA=0 VGS_MAX=3 VGD_MAX=3 VGB_MAX=3 VDS_MAX=3 VDB_MAX=1.6 VSB_MAX=1.6
model hvp_w21753n_l2000n_ng3 PSP103VA TYPE=-1 TR=27 DTA=0 SWGEO=1 SWIGATE=1 SWIMPACT=1 SWGIDL=1 SWJUNCAP=3 SWJUNASYM=0 SWNUD=0 SWEDGE=0 SWDELVTAC=0 SWIGN=1 QMC=1 LVARO=-1.735e-09 LVARL=0 LVARW=0 LAP=3.471e-08 WVARO=0 WVARL=0 WVARW=0 WOT=0 DLQ=3.537e-08 DWQ=3e-08 VFBO=-1.0717 VFBL=-0.03 VFBW=0 VFBLW=0 STVFBO=0.00057379 STVFBL=8.6794e-05 STVFBW=4.9309e-05 STVFBLW=-3.6436e-05 ST2VFBO=0 TOXO=6.945e-09 EPSROXO=3.9 NSUBO=4.2268e+23 NSUBW=0.01112 WSEG=5.362e-08 NPCK=8.0711e+23 NPCKW=-0.011403 WSEGP=1e-06 LPCK=8.3733e-09 LPCKW=0.077499 FOL1=0.065253 FOL2=0.010199 FACNEFFACO=1 FACNEFFACL=0 FACNEFFACW=0 FACNEFFACLW=0 GFACNUDO=1 GFACNUDL=0 GFACNUDLEXP=1 GFACNUDW=0 GFACNUDLW=0 VSBNUDO=0 DVSBNUDO=1 VNSUBO=0 NSLPO=0.05 DNSUBO=0.03585 DPHIBO=-0.077884807 DPHIBL=0.00526388544 DPHIBLEXP=2.1893 DPHIBW=-0.011141504 DPHIBLW=-9.3915789e-05 DELVTACO=0 DELVTACL=0 DELVTACLEXP=1 DELVTACW=0 DELVTACLW=0 NPO=1.092e+26 NPL=0.2188 TOXOVO=6.945e-09 TOXOVDO=2e-09 LOV=3.471e-08 LOVD=0 NOVO=1.99e+26 NOVDO=5e+25 CTO=-0.006328 CTL=0 CTLEXP=1 CTW=0.3006 CTLW=-0.01196 CTGO=0 CTBO=0 STCTO=1 CFL=0.00045884 CFLEXP=2.2055 CFW=0.45909 CFBO=1 CFDO=0 PSCEL=0 PSCELEXP=2 PSCEW=0 PSCEBO=0 PSCEDO=0 UO=0.018428 FBET1=0.15952 FBET1W=-2.1872 LP1=9.9822e-08 LP1W=-1.0871 FBET2=-2.7066 LP2=5.8401e-08 BETW1=-0.097534 BETW2=0.022314 WBET=7.9844e-10 STBETO=1.6489 STBETL=0.029528 STBETW=0.037078 STBETLW=0.046991 MUEO=1.7444601 MUEW=-0.06367 STMUEO=1.0816 THEMUO=1.0324 STTHEMUO=0.26337 CSO=0.18648 CSL=0.21903 CSLEXP=2.0917 CSW=0.0072837 CSLW=0.02 STCSO=2 THECSO=2 STTHECSO=0 XCORO=0.001363 XCORL=8 XCORW=0.0060537 XCORLW=0.058951 STXCORO=-6.939e-18 FETAO=1.2853 RSW1=1970 RSW2=-0.057547 STRSO=-0.24812 RSBO=0.074639 RSGO=0.23490984 THESATO=8.4917e-05 THESATL=0.0067396 THESATLEXP=2.395 THESATW=1.1549 THESATLW=-0.01 STTHESATO=3.0405 STTHESATL=-0.16001 STTHESATW=-0.96988 STTHESATLW=0.36213 THESATBO=0.1 THESATGO=0.6304 AXO=16.822 AXL=3.0092 ALPL=0.0058454 ALPLEXP=0.47562 ALPW=-0.065973 ALP1L1=4.4409e-16 ALP1LEXP=1.347 ALP1L2=1 ALP1W=2 ALP2L1=3.6779e-06 ALP2LEXP=0.2531 ALP2L2=2.2204e-15 ALP2W=0.9582 VPO=1.8436e-06 A1O=47.788 A1L=0.029145 A1W=0.01435 A2O=38.581 STA2O=-0.0049931 A3O=1.1753 A3L=-0.069795 A3W=0.0032538 A4O=0.12593 A4L=-0.07 A4W=-0.04811 GCOO=0 IGINVLW=0 IGOVW=0 IGOVDW=0 STIGO=2 GC2O=0.375 GC3O=0.063 CHIBO=3.1 AGIDLW=6e-10 AGIDLDW=0 BGIDLO=5.5970304 BGIDLDO=41 STBGIDLO=-0.0049461 STBGIDLDO=0 CGIDLO=0.23693 CGIDLDO=0 CGBOVL=-4.669e-16 CFRDW=0 FNTO=1 FNTEXCL=0 NFALW=1.3e+25 NFBLW=5289000000 NFCLW=2e-07 EFO=1.152 LINTNOI=2.5e-08 ALPNOI=2 WEDGE=1e-08 WEDGEW=0 VFBEDGEO=-1 STVFBEDGEO=0.0005 STVFBEDGEL=0 STVFBEDGEW=0 STVFBEDGELW=0 DPHIBEDGEO=0 DPHIBEDGEL=0 DPHIBEDGELEXP=1 DPHIBEDGEW=0 DPHIBEDGELW=0 NSUBEDGEO=5e+23 NSUBEDGEL=0 NSUBEDGELEXP=1 NSUBEDGEW=0 NSUBEDGELW=0 CTEDGEO=0 CTEDGEL=0 CTEDGELEXP=1 FBETEDGE=0 LPEDGE=1e-08 BETEDGEW=0 STBETEDGEO=1 STBETEDGEL=0 STBETEDGEW=0 STBETEDGELW=0 PSCEEDGEL=0 PSCEEDGELEXP=2 PSCEEDGEW=0 PSCEBEDGEO=0 PSCEDEDGEO=0 CFEDGEL=0 CFEDGELEXP=2 CFEDGEW=0 CFDEDGEO=0 CFBEDGEO=0 FNTEDGEO=1 NFAEDGELW=8e+22 NFBEDGELW=30000000 NFCEDGELW=0 EFEDGEO=1 SAREF=1e-06 SBREF=1e-06 WLOD=0 KUO=0 KVSAT=0 TKUO=0 LKUO=0 WKUO=0 PKUO=0 LLODKUO=0 WLODKUO=0 KVTHO=0 LKVTHO=0 WKVTHO=0 PKVTHO=0 LLODVTH=0 WLODVTH=0 STETAO=0 LODETAO=1 SCREF=1e-06 WEB=0 WEC=0 KVTHOWEO=0 KVTHOWEL=0 KVTHOWEW=0 KVTHOWELW=0 KUOWEO=0 KUOWEL=0 KUOWEW=0 KUOWELW=0 TRJ=21 SWJUNEXP=0 IMAX=0.0024527 FREV=1000 CJORBOT=0.0008095 CJORSTI=4.2583e-11 CJORGAT=3.1e-11 VBIRBOT=0.72606 VBIRSTI=0.69819 VBIRGAT=1.199 PBOT=0.33078 PSTI=0.22409 PGAT=0.4474 CJORBOTD=0.001 CJORSTID=1e-09 CJORGATD=1e-09 VBIRBOTD=1 VBIRSTID=1 VBIRGATD=1 PBOTD=0.5 PSTID=0.5 PGATD=0.5 PHIGBOT=1.0641 PHIGSTI=1.3946 PHIGGAT=1.83 IDSATRBOT=3.0606e-08 IDSATRSTI=3.6127e-15 IDSATRGAT=0 CSRHBOT=100 CSRHSTI=0.0001 CSRHGAT=0.0001 XJUNSTI=4.93e-08 XJUNGAT=7.062e-07 PHIGBOTD=1.16 PHIGSTID=1.16 PHIGGATD=1.16 IDSATRBOTD=1e-12 IDSATRSTID=1e-18 IDSATRGATD=1e-18 CSRHBOTD=100 CSRHSTID=0.0001 CSRHGATD=0.0001 XJUNSTID=1e-07 XJUNGATD=1e-07 CTATBOT=100 CTATSTI=0.0001 CTATGAT=0.0001 MEFFTATBOT=0.25 MEFFTATSTI=0.25 MEFFTATGAT=0.25 CTATBOTD=100 CTATSTID=0.0001 CTATGATD=0.0001 MEFFTATBOTD=0.25 MEFFTATSTID=0.25 MEFFTATGATD=0.25 CBBTBOT=1e-12 CBBTSTI=1e-21 CBBTGAT=1e-18 FBBTRBOT=1000000000 FBBTRSTI=1000000000 FBBTRGAT=1000000000 STFBBTBOT=-0.001 STFBBTSTI=-0.001 STFBBTGAT=-0.001 CBBTBOTD=1e-12 CBBTSTID=1e-18 CBBTGATD=1e-18 FBBTRBOTD=1000000000 FBBTRSTID=1000000000 FBBTRGATD=1000000000 STFBBTBOTD=-0.001 STFBBTSTID=-0.001 STFBBTGATD=-0.001 VBRBOT=10 VBRSTI=10 VBRGAT=10 PBRBOT=4 PBRSTI=4 PBRGAT=4 VBRBOTD=10 VBRSTID=10 VBRGATD=10 PBRBOTD=4 PBRSTID=4 PBRGATD=4 VJUNREF=2.5 FJUNQ=0.03 VJUNREFD=2.5 FJUNQD=0.03 RINT=0 RVPOLY=0 DLSIL=0 RSH=0 RSHD=0 CFRW=0 RSHG=40 RGO=15 RBULKO=275.8259828 RWELLO=137.9129914 RJUNSO=459.7099713 RJUNDO=459.7099713 SWSOA=0 VGS_MAX=3 VGD_MAX=3 VGB_MAX=3 VDS_MAX=3 VDB_MAX=1.6 VSB_MAX=1.6
model hvp_w22635n_l2000n_ng3 PSP103VA TYPE=-1 TR=27 DTA=0 SWGEO=1 SWIGATE=1 SWIMPACT=1 SWGIDL=1 SWJUNCAP=3 SWJUNASYM=0 SWNUD=0 SWEDGE=0 SWDELVTAC=0 SWIGN=1 QMC=1 LVARO=-1.735e-09 LVARL=0 LVARW=0 LAP=3.471e-08 WVARO=0 WVARL=0 WVARW=0 WOT=0 DLQ=3.537e-08 DWQ=3e-08 VFBO=-1.0717 VFBL=-0.03 VFBW=0 VFBLW=0 STVFBO=0.00057379 STVFBL=8.6794e-05 STVFBW=4.9309e-05 STVFBLW=-3.6436e-05 ST2VFBO=0 TOXO=6.945e-09 EPSROXO=3.9 NSUBO=4.2268e+23 NSUBW=0.01112 WSEG=5.362e-08 NPCK=8.0711e+23 NPCKW=-0.011403 WSEGP=1e-06 LPCK=8.3733e-09 LPCKW=0.077499 FOL1=0.065253 FOL2=0.010199 FACNEFFACO=1 FACNEFFACL=0 FACNEFFACW=0 FACNEFFACLW=0 GFACNUDO=1 GFACNUDL=0 GFACNUDLEXP=1 GFACNUDW=0 GFACNUDLW=0 VSBNUDO=0 DVSBNUDO=1 VNSUBO=0 NSLPO=0.05 DNSUBO=0.03585 DPHIBO=-0.077884807 DPHIBL=0.00526388544 DPHIBLEXP=2.1893 DPHIBW=-0.011141504 DPHIBLW=-9.3915789e-05 DELVTACO=0 DELVTACL=0 DELVTACLEXP=1 DELVTACW=0 DELVTACLW=0 NPO=1.092e+26 NPL=0.2188 TOXOVO=6.945e-09 TOXOVDO=2e-09 LOV=3.471e-08 LOVD=0 NOVO=1.99e+26 NOVDO=5e+25 CTO=-0.006328 CTL=0 CTLEXP=1 CTW=0.3006 CTLW=-0.01196 CTGO=0 CTBO=0 STCTO=1 CFL=0.00045884 CFLEXP=2.2055 CFW=0.45909 CFBO=1 CFDO=0 PSCEL=0 PSCELEXP=2 PSCEW=0 PSCEBO=0 PSCEDO=0 UO=0.018428 FBET1=0.15952 FBET1W=-2.1872 LP1=9.9822e-08 LP1W=-1.0871 FBET2=-2.7066 LP2=5.8401e-08 BETW1=-0.097534 BETW2=0.022314 WBET=7.9844e-10 STBETO=1.6489 STBETL=0.029528 STBETW=0.037078 STBETLW=0.046991 MUEO=1.7444601 MUEW=-0.06367 STMUEO=1.0816 THEMUO=1.0324 STTHEMUO=0.26337 CSO=0.18648 CSL=0.21903 CSLEXP=2.0917 CSW=0.0072837 CSLW=0.02 STCSO=2 THECSO=2 STTHECSO=0 XCORO=0.001363 XCORL=8 XCORW=0.0060537 XCORLW=0.058951 STXCORO=-6.939e-18 FETAO=1.2853 RSW1=1970 RSW2=-0.057547 STRSO=-0.24812 RSBO=0.074639 RSGO=0.23490984 THESATO=8.4917e-05 THESATL=0.0067396 THESATLEXP=2.395 THESATW=1.1549 THESATLW=-0.01 STTHESATO=3.0405 STTHESATL=-0.16001 STTHESATW=-0.96988 STTHESATLW=0.36213 THESATBO=0.1 THESATGO=0.6304 AXO=16.822 AXL=3.0092 ALPL=0.0058454 ALPLEXP=0.47562 ALPW=-0.065973 ALP1L1=4.4409e-16 ALP1LEXP=1.347 ALP1L2=1 ALP1W=2 ALP2L1=3.6779e-06 ALP2LEXP=0.2531 ALP2L2=2.2204e-15 ALP2W=0.9582 VPO=1.8436e-06 A1O=47.788 A1L=0.029145 A1W=0.01435 A2O=38.581 STA2O=-0.0049931 A3O=1.1753 A3L=-0.069795 A3W=0.0032538 A4O=0.12593 A4L=-0.07 A4W=-0.04811 GCOO=0 IGINVLW=0 IGOVW=0 IGOVDW=0 STIGO=2 GC2O=0.375 GC3O=0.063 CHIBO=3.1 AGIDLW=6e-10 AGIDLDW=0 BGIDLO=5.5970304 BGIDLDO=41 STBGIDLO=-0.0049461 STBGIDLDO=0 CGIDLO=0.23693 CGIDLDO=0 CGBOVL=-4.669e-16 CFRDW=0 FNTO=1 FNTEXCL=0 NFALW=1.3e+25 NFBLW=5289000000 NFCLW=2e-07 EFO=1.152 LINTNOI=2.5e-08 ALPNOI=2 WEDGE=1e-08 WEDGEW=0 VFBEDGEO=-1 STVFBEDGEO=0.0005 STVFBEDGEL=0 STVFBEDGEW=0 STVFBEDGELW=0 DPHIBEDGEO=0 DPHIBEDGEL=0 DPHIBEDGELEXP=1 DPHIBEDGEW=0 DPHIBEDGELW=0 NSUBEDGEO=5e+23 NSUBEDGEL=0 NSUBEDGELEXP=1 NSUBEDGEW=0 NSUBEDGELW=0 CTEDGEO=0 CTEDGEL=0 CTEDGELEXP=1 FBETEDGE=0 LPEDGE=1e-08 BETEDGEW=0 STBETEDGEO=1 STBETEDGEL=0 STBETEDGEW=0 STBETEDGELW=0 PSCEEDGEL=0 PSCEEDGELEXP=2 PSCEEDGEW=0 PSCEBEDGEO=0 PSCEDEDGEO=0 CFEDGEL=0 CFEDGELEXP=2 CFEDGEW=0 CFDEDGEO=0 CFBEDGEO=0 FNTEDGEO=1 NFAEDGELW=8e+22 NFBEDGELW=30000000 NFCEDGELW=0 EFEDGEO=1 SAREF=1e-06 SBREF=1e-06 WLOD=0 KUO=0 KVSAT=0 TKUO=0 LKUO=0 WKUO=0 PKUO=0 LLODKUO=0 WLODKUO=0 KVTHO=0 LKVTHO=0 WKVTHO=0 PKVTHO=0 LLODVTH=0 WLODVTH=0 STETAO=0 LODETAO=1 SCREF=1e-06 WEB=0 WEC=0 KVTHOWEO=0 KVTHOWEL=0 KVTHOWEW=0 KVTHOWELW=0 KUOWEO=0 KUOWEL=0 KUOWEW=0 KUOWELW=0 TRJ=21 SWJUNEXP=0 IMAX=0.0024527 FREV=1000 CJORBOT=0.0008095 CJORSTI=4.2583e-11 CJORGAT=3.1e-11 VBIRBOT=0.72606 VBIRSTI=0.69819 VBIRGAT=1.199 PBOT=0.33078 PSTI=0.22409 PGAT=0.4474 CJORBOTD=0.001 CJORSTID=1e-09 CJORGATD=1e-09 VBIRBOTD=1 VBIRSTID=1 VBIRGATD=1 PBOTD=0.5 PSTID=0.5 PGATD=0.5 PHIGBOT=1.0641 PHIGSTI=1.3946 PHIGGAT=1.83 IDSATRBOT=3.0606e-08 IDSATRSTI=3.6127e-15 IDSATRGAT=0 CSRHBOT=100 CSRHSTI=0.0001 CSRHGAT=0.0001 XJUNSTI=4.93e-08 XJUNGAT=7.062e-07 PHIGBOTD=1.16 PHIGSTID=1.16 PHIGGATD=1.16 IDSATRBOTD=1e-12 IDSATRSTID=1e-18 IDSATRGATD=1e-18 CSRHBOTD=100 CSRHSTID=0.0001 CSRHGATD=0.0001 XJUNSTID=1e-07 XJUNGATD=1e-07 CTATBOT=100 CTATSTI=0.0001 CTATGAT=0.0001 MEFFTATBOT=0.25 MEFFTATSTI=0.25 MEFFTATGAT=0.25 CTATBOTD=100 CTATSTID=0.0001 CTATGATD=0.0001 MEFFTATBOTD=0.25 MEFFTATSTID=0.25 MEFFTATGATD=0.25 CBBTBOT=1e-12 CBBTSTI=1e-21 CBBTGAT=1e-18 FBBTRBOT=1000000000 FBBTRSTI=1000000000 FBBTRGAT=1000000000 STFBBTBOT=-0.001 STFBBTSTI=-0.001 STFBBTGAT=-0.001 CBBTBOTD=1e-12 CBBTSTID=1e-18 CBBTGATD=1e-18 FBBTRBOTD=1000000000 FBBTRSTID=1000000000 FBBTRGATD=1000000000 STFBBTBOTD=-0.001 STFBBTSTID=-0.001 STFBBTGATD=-0.001 VBRBOT=10 VBRSTI=10 VBRGAT=10 PBRBOT=4 PBRSTI=4 PBRGAT=4 VBRBOTD=10 VBRSTID=10 VBRGATD=10 PBRBOTD=4 PBRSTID=4 PBRGATD=4 VJUNREF=2.5 FJUNQ=0.03 VJUNREFD=2.5 FJUNQD=0.03 RINT=0 RVPOLY=0 DLSIL=0 RSH=0 RSHD=0 CFRW=0 RSHG=40 RGO=15 RBULKO=265.0736435 RWELLO=132.5368217 RJUNSO=441.7894058 RJUNDO=441.7894058 SWSOA=0 VGS_MAX=3 VGD_MAX=3 VGB_MAX=3 VDS_MAX=3 VDB_MAX=1.6 VSB_MAX=1.6
model hvp_w24000n_l2000n_ng3 PSP103VA TYPE=-1 TR=27 DTA=0 SWGEO=1 SWIGATE=1 SWIMPACT=1 SWGIDL=1 SWJUNCAP=3 SWJUNASYM=0 SWNUD=0 SWEDGE=0 SWDELVTAC=0 SWIGN=1 QMC=1 LVARO=-1.735e-09 LVARL=0 LVARW=0 LAP=3.471e-08 WVARO=0 WVARL=0 WVARW=0 WOT=0 DLQ=3.537e-08 DWQ=3e-08 VFBO=-1.0717 VFBL=-0.03 VFBW=0 VFBLW=0 STVFBO=0.00057379 STVFBL=8.6794e-05 STVFBW=4.9309e-05 STVFBLW=-3.6436e-05 ST2VFBO=0 TOXO=6.945e-09 EPSROXO=3.9 NSUBO=4.2268e+23 NSUBW=0.01112 WSEG=5.362e-08 NPCK=8.0711e+23 NPCKW=-0.011403 WSEGP=1e-06 LPCK=8.3733e-09 LPCKW=0.077499 FOL1=0.065253 FOL2=0.010199 FACNEFFACO=1 FACNEFFACL=0 FACNEFFACW=0 FACNEFFACLW=0 GFACNUDO=1 GFACNUDL=0 GFACNUDLEXP=1 GFACNUDW=0 GFACNUDLW=0 VSBNUDO=0 DVSBNUDO=1 VNSUBO=0 NSLPO=0.05 DNSUBO=0.03585 DPHIBO=-0.077884807 DPHIBL=0.00526388544 DPHIBLEXP=2.1893 DPHIBW=-0.011141504 DPHIBLW=-9.3915789e-05 DELVTACO=0 DELVTACL=0 DELVTACLEXP=1 DELVTACW=0 DELVTACLW=0 NPO=1.092e+26 NPL=0.2188 TOXOVO=6.945e-09 TOXOVDO=2e-09 LOV=3.471e-08 LOVD=0 NOVO=1.99e+26 NOVDO=5e+25 CTO=-0.006328 CTL=0 CTLEXP=1 CTW=0.3006 CTLW=-0.01196 CTGO=0 CTBO=0 STCTO=1 CFL=0.00045884 CFLEXP=2.2055 CFW=0.45909 CFBO=1 CFDO=0 PSCEL=0 PSCELEXP=2 PSCEW=0 PSCEBO=0 PSCEDO=0 UO=0.018428 FBET1=0.15952 FBET1W=-2.1872 LP1=9.9822e-08 LP1W=-1.0871 FBET2=-2.7066 LP2=5.8401e-08 BETW1=-0.097534 BETW2=0.022314 WBET=7.9844e-10 STBETO=1.6489 STBETL=0.029528 STBETW=0.037078 STBETLW=0.046991 MUEO=1.7444601 MUEW=-0.06367 STMUEO=1.0816 THEMUO=1.0324 STTHEMUO=0.26337 CSO=0.18648 CSL=0.21903 CSLEXP=2.0917 CSW=0.0072837 CSLW=0.02 STCSO=2 THECSO=2 STTHECSO=0 XCORO=0.001363 XCORL=8 XCORW=0.0060537 XCORLW=0.058951 STXCORO=-6.939e-18 FETAO=1.2853 RSW1=1970 RSW2=-0.057547 STRSO=-0.24812 RSBO=0.074639 RSGO=0.23490984 THESATO=8.4917e-05 THESATL=0.0067396 THESATLEXP=2.395 THESATW=1.1549 THESATLW=-0.01 STTHESATO=3.0405 STTHESATL=-0.16001 STTHESATW=-0.96988 STTHESATLW=0.36213 THESATBO=0.1 THESATGO=0.6304 AXO=16.822 AXL=3.0092 ALPL=0.0058454 ALPLEXP=0.47562 ALPW=-0.065973 ALP1L1=4.4409e-16 ALP1LEXP=1.347 ALP1L2=1 ALP1W=2 ALP2L1=3.6779e-06 ALP2LEXP=0.2531 ALP2L2=2.2204e-15 ALP2W=0.9582 VPO=1.8436e-06 A1O=47.788 A1L=0.029145 A1W=0.01435 A2O=38.581 STA2O=-0.0049931 A3O=1.1753 A3L=-0.069795 A3W=0.0032538 A4O=0.12593 A4L=-0.07 A4W=-0.04811 GCOO=0 IGINVLW=0 IGOVW=0 IGOVDW=0 STIGO=2 GC2O=0.375 GC3O=0.063 CHIBO=3.1 AGIDLW=6e-10 AGIDLDW=0 BGIDLO=5.5970304 BGIDLDO=41 STBGIDLO=-0.0049461 STBGIDLDO=0 CGIDLO=0.23693 CGIDLDO=0 CGBOVL=-4.669e-16 CFRDW=0 FNTO=1 FNTEXCL=0 NFALW=1.3e+25 NFBLW=5289000000 NFCLW=2e-07 EFO=1.152 LINTNOI=2.5e-08 ALPNOI=2 WEDGE=1e-08 WEDGEW=0 VFBEDGEO=-1 STVFBEDGEO=0.0005 STVFBEDGEL=0 STVFBEDGEW=0 STVFBEDGELW=0 DPHIBEDGEO=0 DPHIBEDGEL=0 DPHIBEDGELEXP=1 DPHIBEDGEW=0 DPHIBEDGELW=0 NSUBEDGEO=5e+23 NSUBEDGEL=0 NSUBEDGELEXP=1 NSUBEDGEW=0 NSUBEDGELW=0 CTEDGEO=0 CTEDGEL=0 CTEDGELEXP=1 FBETEDGE=0 LPEDGE=1e-08 BETEDGEW=0 STBETEDGEO=1 STBETEDGEL=0 STBETEDGEW=0 STBETEDGELW=0 PSCEEDGEL=0 PSCEEDGELEXP=2 PSCEEDGEW=0 PSCEBEDGEO=0 PSCEDEDGEO=0 CFEDGEL=0 CFEDGELEXP=2 CFEDGEW=0 CFDEDGEO=0 CFBEDGEO=0 FNTEDGEO=1 NFAEDGELW=8e+22 NFBEDGELW=30000000 NFCEDGELW=0 EFEDGEO=1 SAREF=1e-06 SBREF=1e-06 WLOD=0 KUO=0 KVSAT=0 TKUO=0 LKUO=0 WKUO=0 PKUO=0 LLODKUO=0 WLODKUO=0 KVTHO=0 LKVTHO=0 WKVTHO=0 PKVTHO=0 LLODVTH=0 WLODVTH=0 STETAO=0 LODETAO=1 SCREF=1e-06 WEB=0 WEC=0 KVTHOWEO=0 KVTHOWEL=0 KVTHOWEW=0 KVTHOWELW=0 KUOWEO=0 KUOWEL=0 KUOWEW=0 KUOWELW=0 TRJ=21 SWJUNEXP=0 IMAX=0.0024527 FREV=1000 CJORBOT=0.0008095 CJORSTI=4.2583e-11 CJORGAT=3.1e-11 VBIRBOT=0.72606 VBIRSTI=0.69819 VBIRGAT=1.199 PBOT=0.33078 PSTI=0.22409 PGAT=0.4474 CJORBOTD=0.001 CJORSTID=1e-09 CJORGATD=1e-09 VBIRBOTD=1 VBIRSTID=1 VBIRGATD=1 PBOTD=0.5 PSTID=0.5 PGATD=0.5 PHIGBOT=1.0641 PHIGSTI=1.3946 PHIGGAT=1.83 IDSATRBOT=3.0606e-08 IDSATRSTI=3.6127e-15 IDSATRGAT=0 CSRHBOT=100 CSRHSTI=0.0001 CSRHGAT=0.0001 XJUNSTI=4.93e-08 XJUNGAT=7.062e-07 PHIGBOTD=1.16 PHIGSTID=1.16 PHIGGATD=1.16 IDSATRBOTD=1e-12 IDSATRSTID=1e-18 IDSATRGATD=1e-18 CSRHBOTD=100 CSRHSTID=0.0001 CSRHGATD=0.0001 XJUNSTID=1e-07 XJUNGATD=1e-07 CTATBOT=100 CTATSTI=0.0001 CTATGAT=0.0001 MEFFTATBOT=0.25 MEFFTATSTI=0.25 MEFFTATGAT=0.25 CTATBOTD=100 CTATSTID=0.0001 CTATGATD=0.0001 MEFFTATBOTD=0.25 MEFFTATSTID=0.25 MEFFTATGATD=0.25 CBBTBOT=1e-12 CBBTSTI=1e-21 CBBTGAT=1e-18 FBBTRBOT=1000000000 FBBTRSTI=1000000000 FBBTRGAT=1000000000 STFBBTBOT=-0.001 STFBBTSTI=-0.001 STFBBTGAT=-0.001 CBBTBOTD=1e-12 CBBTSTID=1e-18 CBBTGATD=1e-18 FBBTRBOTD=1000000000 FBBTRSTID=1000000000 FBBTRGATD=1000000000 STFBBTBOTD=-0.001 STFBBTSTID=-0.001 STFBBTGATD=-0.001 VBRBOT=10 VBRSTI=10 VBRGAT=10 PBRBOT=4 PBRSTI=4 PBRGAT=4 VBRBOTD=10 VBRSTID=10 VBRGATD=10 PBRBOTD=4 PBRSTID=4 PBRGATD=4 VJUNREF=2.5 FJUNQ=0.03 VJUNREFD=2.5 FJUNQD=0.03 RINT=0 RVPOLY=0 DLSIL=0 RSH=0 RSHD=0 CFRW=0 RSHG=40 RGO=15 RBULKO=250 RWELLO=125 RJUNSO=416.6666667 RJUNDO=416.6666667 SWSOA=0 VGS_MAX=3 VGD_MAX=3 VGB_MAX=3 VDS_MAX=3 VDB_MAX=1.6 VSB_MAX=1.6
model hvp_w34101n_l2000n_ng4 PSP103VA TYPE=-1 TR=27 DTA=0 SWGEO=1 SWIGATE=1 SWIMPACT=1 SWGIDL=1 SWJUNCAP=3 SWJUNASYM=0 SWNUD=0 SWEDGE=0 SWDELVTAC=0 SWIGN=1 QMC=1 LVARO=-1.735e-09 LVARL=0 LVARW=0 LAP=3.471e-08 WVARO=0 WVARL=0 WVARW=0 WOT=0 DLQ=3.537e-08 DWQ=3e-08 VFBO=-1.0717 VFBL=-0.03 VFBW=0 VFBLW=0 STVFBO=0.00057379 STVFBL=8.6794e-05 STVFBW=4.9309e-05 STVFBLW=-3.6436e-05 ST2VFBO=0 TOXO=6.945e-09 EPSROXO=3.9 NSUBO=4.2268e+23 NSUBW=0.01112 WSEG=5.362e-08 NPCK=8.0711e+23 NPCKW=-0.011403 WSEGP=1e-06 LPCK=8.3733e-09 LPCKW=0.077499 FOL1=0.065253 FOL2=0.010199 FACNEFFACO=1 FACNEFFACL=0 FACNEFFACW=0 FACNEFFACLW=0 GFACNUDO=1 GFACNUDL=0 GFACNUDLEXP=1 GFACNUDW=0 GFACNUDLW=0 VSBNUDO=0 DVSBNUDO=1 VNSUBO=0 NSLPO=0.05 DNSUBO=0.03585 DPHIBO=-0.077884807 DPHIBL=0.00526388544 DPHIBLEXP=2.1893 DPHIBW=-0.011141504 DPHIBLW=-9.3915789e-05 DELVTACO=0 DELVTACL=0 DELVTACLEXP=1 DELVTACW=0 DELVTACLW=0 NPO=1.092e+26 NPL=0.2188 TOXOVO=6.945e-09 TOXOVDO=2e-09 LOV=3.471e-08 LOVD=0 NOVO=1.99e+26 NOVDO=5e+25 CTO=-0.006328 CTL=0 CTLEXP=1 CTW=0.3006 CTLW=-0.01196 CTGO=0 CTBO=0 STCTO=1 CFL=0.00045884 CFLEXP=2.2055 CFW=0.45909 CFBO=1 CFDO=0 PSCEL=0 PSCELEXP=2 PSCEW=0 PSCEBO=0 PSCEDO=0 UO=0.018428 FBET1=0.15952 FBET1W=-2.1872 LP1=9.9822e-08 LP1W=-1.0871 FBET2=-2.7066 LP2=5.8401e-08 BETW1=-0.097534 BETW2=0.022314 WBET=7.9844e-10 STBETO=1.6489 STBETL=0.029528 STBETW=0.037078 STBETLW=0.046991 MUEO=1.7444601 MUEW=-0.06367 STMUEO=1.0816 THEMUO=1.0324 STTHEMUO=0.26337 CSO=0.18648 CSL=0.21903 CSLEXP=2.0917 CSW=0.0072837 CSLW=0.02 STCSO=2 THECSO=2 STTHECSO=0 XCORO=0.001363 XCORL=8 XCORW=0.0060537 XCORLW=0.058951 STXCORO=-6.939e-18 FETAO=1.2853 RSW1=1970 RSW2=-0.057547 STRSO=-0.24812 RSBO=0.074639 RSGO=0.23490984 THESATO=8.4917e-05 THESATL=0.0067396 THESATLEXP=2.395 THESATW=1.1549 THESATLW=-0.01 STTHESATO=3.0405 STTHESATL=-0.16001 STTHESATW=-0.96988 STTHESATLW=0.36213 THESATBO=0.1 THESATGO=0.6304 AXO=16.822 AXL=3.0092 ALPL=0.0058454 ALPLEXP=0.47562 ALPW=-0.065973 ALP1L1=4.4409e-16 ALP1LEXP=1.347 ALP1L2=1 ALP1W=2 ALP2L1=3.6779e-06 ALP2LEXP=0.2531 ALP2L2=2.2204e-15 ALP2W=0.9582 VPO=1.8436e-06 A1O=47.788 A1L=0.029145 A1W=0.01435 A2O=38.581 STA2O=-0.0049931 A3O=1.1753 A3L=-0.069795 A3W=0.0032538 A4O=0.12593 A4L=-0.07 A4W=-0.04811 GCOO=0 IGINVLW=0 IGOVW=0 IGOVDW=0 STIGO=2 GC2O=0.375 GC3O=0.063 CHIBO=3.1 AGIDLW=6e-10 AGIDLDW=0 BGIDLO=5.5970304 BGIDLDO=41 STBGIDLO=-0.0049461 STBGIDLDO=0 CGIDLO=0.23693 CGIDLDO=0 CGBOVL=-4.669e-16 CFRDW=0 FNTO=1 FNTEXCL=0 NFALW=1.3e+25 NFBLW=5289000000 NFCLW=2e-07 EFO=1.152 LINTNOI=2.5e-08 ALPNOI=2 WEDGE=1e-08 WEDGEW=0 VFBEDGEO=-1 STVFBEDGEO=0.0005 STVFBEDGEL=0 STVFBEDGEW=0 STVFBEDGELW=0 DPHIBEDGEO=0 DPHIBEDGEL=0 DPHIBEDGELEXP=1 DPHIBEDGEW=0 DPHIBEDGELW=0 NSUBEDGEO=5e+23 NSUBEDGEL=0 NSUBEDGELEXP=1 NSUBEDGEW=0 NSUBEDGELW=0 CTEDGEO=0 CTEDGEL=0 CTEDGELEXP=1 FBETEDGE=0 LPEDGE=1e-08 BETEDGEW=0 STBETEDGEO=1 STBETEDGEL=0 STBETEDGEW=0 STBETEDGELW=0 PSCEEDGEL=0 PSCEEDGELEXP=2 PSCEEDGEW=0 PSCEBEDGEO=0 PSCEDEDGEO=0 CFEDGEL=0 CFEDGELEXP=2 CFEDGEW=0 CFDEDGEO=0 CFBEDGEO=0 FNTEDGEO=1 NFAEDGELW=8e+22 NFBEDGELW=30000000 NFCEDGELW=0 EFEDGEO=1 SAREF=1e-06 SBREF=1e-06 WLOD=0 KUO=0 KVSAT=0 TKUO=0 LKUO=0 WKUO=0 PKUO=0 LLODKUO=0 WLODKUO=0 KVTHO=0 LKVTHO=0 WKVTHO=0 PKVTHO=0 LLODVTH=0 WLODVTH=0 STETAO=0 LODETAO=1 SCREF=1e-06 WEB=0 WEC=0 KVTHOWEO=0 KVTHOWEL=0 KVTHOWEW=0 KVTHOWELW=0 KUOWEO=0 KUOWEL=0 KUOWEW=0 KUOWELW=0 TRJ=21 SWJUNEXP=0 IMAX=0.0024527 FREV=1000 CJORBOT=0.0008095 CJORSTI=4.2583e-11 CJORGAT=3.1e-11 VBIRBOT=0.72606 VBIRSTI=0.69819 VBIRGAT=1.199 PBOT=0.33078 PSTI=0.22409 PGAT=0.4474 CJORBOTD=0.001 CJORSTID=1e-09 CJORGATD=1e-09 VBIRBOTD=1 VBIRSTID=1 VBIRGATD=1 PBOTD=0.5 PSTID=0.5 PGATD=0.5 PHIGBOT=1.0641 PHIGSTI=1.3946 PHIGGAT=1.83 IDSATRBOT=3.0606e-08 IDSATRSTI=3.6127e-15 IDSATRGAT=0 CSRHBOT=100 CSRHSTI=0.0001 CSRHGAT=0.0001 XJUNSTI=4.93e-08 XJUNGAT=7.062e-07 PHIGBOTD=1.16 PHIGSTID=1.16 PHIGGATD=1.16 IDSATRBOTD=1e-12 IDSATRSTID=1e-18 IDSATRGATD=1e-18 CSRHBOTD=100 CSRHSTID=0.0001 CSRHGATD=0.0001 XJUNSTID=1e-07 XJUNGATD=1e-07 CTATBOT=100 CTATSTI=0.0001 CTATGAT=0.0001 MEFFTATBOT=0.25 MEFFTATSTI=0.25 MEFFTATGAT=0.25 CTATBOTD=100 CTATSTID=0.0001 CTATGATD=0.0001 MEFFTATBOTD=0.25 MEFFTATSTID=0.25 MEFFTATGATD=0.25 CBBTBOT=1e-12 CBBTSTI=1e-21 CBBTGAT=1e-18 FBBTRBOT=1000000000 FBBTRSTI=1000000000 FBBTRGAT=1000000000 STFBBTBOT=-0.001 STFBBTSTI=-0.001 STFBBTGAT=-0.001 CBBTBOTD=1e-12 CBBTSTID=1e-18 CBBTGATD=1e-18 FBBTRBOTD=1000000000 FBBTRSTID=1000000000 FBBTRGATD=1000000000 STFBBTBOTD=-0.001 STFBBTSTID=-0.001 STFBBTGATD=-0.001 VBRBOT=10 VBRSTI=10 VBRGAT=10 PBRBOT=4 PBRSTI=4 PBRGAT=4 VBRBOTD=10 VBRSTID=10 VBRGATD=10 PBRBOTD=4 PBRSTID=4 PBRGATD=4 VJUNREF=2.5 FJUNQ=0.03 VJUNREFD=2.5 FJUNQD=0.03 RINT=0 RVPOLY=0 DLSIL=0 RSH=0 RSHD=0 CFRW=0 RSHG=40 RGO=15 RBULKO=234.5984 RWELLO=117.2992 RJUNSO=293.248 RJUNDO=293.248 SWSOA=0 VGS_MAX=3 VGD_MAX=3 VGB_MAX=3 VDS_MAX=3 VDB_MAX=1.6 VSB_MAX=1.6
model hvp_w34101n_l400n_ng4 PSP103VA TYPE=-1 TR=27 DTA=0 SWGEO=1 SWIGATE=1 SWIMPACT=1 SWGIDL=1 SWJUNCAP=3 SWJUNASYM=0 SWNUD=0 SWEDGE=0 SWDELVTAC=0 SWIGN=1 QMC=1 LVARO=-1.735e-09 LVARL=0 LVARW=0 LAP=3.471e-08 WVARO=0 WVARL=0 WVARW=0 WOT=0 DLQ=3.537e-08 DWQ=3e-08 VFBO=-1.0717 VFBL=-0.03 VFBW=0 VFBLW=0 STVFBO=0.00057379 STVFBL=8.6794e-05 STVFBW=4.9309e-05 STVFBLW=-3.6436e-05 ST2VFBO=0 TOXO=6.945e-09 EPSROXO=3.9 NSUBO=4.2268e+23 NSUBW=0.01112 WSEG=5.362e-08 NPCK=8.0711e+23 NPCKW=-0.011403 WSEGP=1e-06 LPCK=8.3733e-09 LPCKW=0.077499 FOL1=0.065253 FOL2=0.010199 FACNEFFACO=1 FACNEFFACL=0 FACNEFFACW=0 FACNEFFACLW=0 GFACNUDO=1 GFACNUDL=0 GFACNUDLEXP=1 GFACNUDW=0 GFACNUDLW=0 VSBNUDO=0 DVSBNUDO=1 VNSUBO=0 NSLPO=0.05 DNSUBO=0.03585 DPHIBO=-0.077884807 DPHIBL=0.00526388544 DPHIBLEXP=2.1893 DPHIBW=-0.011141504 DPHIBLW=-9.3915789e-05 DELVTACO=0 DELVTACL=0 DELVTACLEXP=1 DELVTACW=0 DELVTACLW=0 NPO=1.092e+26 NPL=0.2188 TOXOVO=6.945e-09 TOXOVDO=2e-09 LOV=3.471e-08 LOVD=0 NOVO=1.99e+26 NOVDO=5e+25 CTO=-0.006328 CTL=0 CTLEXP=1 CTW=0.3006 CTLW=-0.01196 CTGO=0 CTBO=0 STCTO=1 CFL=0.00045884 CFLEXP=2.2055 CFW=0.45909 CFBO=1 CFDO=0 PSCEL=0 PSCELEXP=2 PSCEW=0 PSCEBO=0 PSCEDO=0 UO=0.018428 FBET1=0.15952 FBET1W=-2.1872 LP1=9.9822e-08 LP1W=-1.0871 FBET2=-2.7066 LP2=5.8401e-08 BETW1=-0.097534 BETW2=0.022314 WBET=7.9844e-10 STBETO=1.6489 STBETL=0.029528 STBETW=0.037078 STBETLW=0.046991 MUEO=1.7444601 MUEW=-0.06367 STMUEO=1.0816 THEMUO=1.0324 STTHEMUO=0.26337 CSO=0.18648 CSL=0.21903 CSLEXP=2.0917 CSW=0.0072837 CSLW=0.02 STCSO=2 THECSO=2 STTHECSO=0 XCORO=0.001363 XCORL=8 XCORW=0.0060537 XCORLW=0.058951 STXCORO=-6.939e-18 FETAO=1.2853 RSW1=1970 RSW2=-0.057547 STRSO=-0.24812 RSBO=0.074639 RSGO=0.23490984 THESATO=8.4917e-05 THESATL=0.0067396 THESATLEXP=2.395 THESATW=1.1549 THESATLW=-0.01 STTHESATO=3.0405 STTHESATL=-0.16001 STTHESATW=-0.96988 STTHESATLW=0.36213 THESATBO=0.1 THESATGO=0.6304 AXO=16.822 AXL=3.0092 ALPL=0.0058454 ALPLEXP=0.47562 ALPW=-0.065973 ALP1L1=4.4409e-16 ALP1LEXP=1.347 ALP1L2=1 ALP1W=2 ALP2L1=3.6779e-06 ALP2LEXP=0.2531 ALP2L2=2.2204e-15 ALP2W=0.9582 VPO=1.8436e-06 A1O=47.788 A1L=0.029145 A1W=0.01435 A2O=38.581 STA2O=-0.0049931 A3O=1.1753 A3L=-0.069795 A3W=0.0032538 A4O=0.12593 A4L=-0.07 A4W=-0.04811 GCOO=0 IGINVLW=0 IGOVW=0 IGOVDW=0 STIGO=2 GC2O=0.375 GC3O=0.063 CHIBO=3.1 AGIDLW=6e-10 AGIDLDW=0 BGIDLO=5.5970304 BGIDLDO=41 STBGIDLO=-0.0049461 STBGIDLDO=0 CGIDLO=0.23693 CGIDLDO=0 CGBOVL=-4.669e-16 CFRDW=0 FNTO=1 FNTEXCL=0 NFALW=1.3e+25 NFBLW=5289000000 NFCLW=2e-07 EFO=1.152 LINTNOI=2.5e-08 ALPNOI=2 WEDGE=1e-08 WEDGEW=0 VFBEDGEO=-1 STVFBEDGEO=0.0005 STVFBEDGEL=0 STVFBEDGEW=0 STVFBEDGELW=0 DPHIBEDGEO=0 DPHIBEDGEL=0 DPHIBEDGELEXP=1 DPHIBEDGEW=0 DPHIBEDGELW=0 NSUBEDGEO=5e+23 NSUBEDGEL=0 NSUBEDGELEXP=1 NSUBEDGEW=0 NSUBEDGELW=0 CTEDGEO=0 CTEDGEL=0 CTEDGELEXP=1 FBETEDGE=0 LPEDGE=1e-08 BETEDGEW=0 STBETEDGEO=1 STBETEDGEL=0 STBETEDGEW=0 STBETEDGELW=0 PSCEEDGEL=0 PSCEEDGELEXP=2 PSCEEDGEW=0 PSCEBEDGEO=0 PSCEDEDGEO=0 CFEDGEL=0 CFEDGELEXP=2 CFEDGEW=0 CFDEDGEO=0 CFBEDGEO=0 FNTEDGEO=1 NFAEDGELW=8e+22 NFBEDGELW=30000000 NFCEDGELW=0 EFEDGEO=1 SAREF=1e-06 SBREF=1e-06 WLOD=0 KUO=0 KVSAT=0 TKUO=0 LKUO=0 WKUO=0 PKUO=0 LLODKUO=0 WLODKUO=0 KVTHO=0 LKVTHO=0 WKVTHO=0 PKVTHO=0 LLODVTH=0 WLODVTH=0 STETAO=0 LODETAO=1 SCREF=1e-06 WEB=0 WEC=0 KVTHOWEO=0 KVTHOWEL=0 KVTHOWEW=0 KVTHOWELW=0 KUOWEO=0 KUOWEL=0 KUOWEW=0 KUOWELW=0 TRJ=21 SWJUNEXP=0 IMAX=0.0024527 FREV=1000 CJORBOT=0.0008095 CJORSTI=4.2583e-11 CJORGAT=3.1e-11 VBIRBOT=0.72606 VBIRSTI=0.69819 VBIRGAT=1.199 PBOT=0.33078 PSTI=0.22409 PGAT=0.4474 CJORBOTD=0.001 CJORSTID=1e-09 CJORGATD=1e-09 VBIRBOTD=1 VBIRSTID=1 VBIRGATD=1 PBOTD=0.5 PSTID=0.5 PGATD=0.5 PHIGBOT=1.0641 PHIGSTI=1.3946 PHIGGAT=1.83 IDSATRBOT=3.0606e-08 IDSATRSTI=3.6127e-15 IDSATRGAT=0 CSRHBOT=100 CSRHSTI=0.0001 CSRHGAT=0.0001 XJUNSTI=4.93e-08 XJUNGAT=7.062e-07 PHIGBOTD=1.16 PHIGSTID=1.16 PHIGGATD=1.16 IDSATRBOTD=1e-12 IDSATRSTID=1e-18 IDSATRGATD=1e-18 CSRHBOTD=100 CSRHSTID=0.0001 CSRHGATD=0.0001 XJUNSTID=1e-07 XJUNGATD=1e-07 CTATBOT=100 CTATSTI=0.0001 CTATGAT=0.0001 MEFFTATBOT=0.25 MEFFTATSTI=0.25 MEFFTATGAT=0.25 CTATBOTD=100 CTATSTID=0.0001 CTATGATD=0.0001 MEFFTATBOTD=0.25 MEFFTATSTID=0.25 MEFFTATGATD=0.25 CBBTBOT=1e-12 CBBTSTI=1e-21 CBBTGAT=1e-18 FBBTRBOT=1000000000 FBBTRSTI=1000000000 FBBTRGAT=1000000000 STFBBTBOT=-0.001 STFBBTSTI=-0.001 STFBBTGAT=-0.001 CBBTBOTD=1e-12 CBBTSTID=1e-18 CBBTGATD=1e-18 FBBTRBOTD=1000000000 FBBTRSTID=1000000000 FBBTRGATD=1000000000 STFBBTBOTD=-0.001 STFBBTSTID=-0.001 STFBBTGATD=-0.001 VBRBOT=10 VBRSTI=10 VBRGAT=10 PBRBOT=4 PBRSTI=4 PBRGAT=4 VBRBOTD=10 VBRSTID=10 VBRGATD=10 PBRBOTD=4 PBRSTID=4 PBRGATD=4 VJUNREF=2.5 FJUNQ=0.03 VJUNREFD=2.5 FJUNQD=0.03 RINT=0 RVPOLY=0 DLSIL=0 RSH=0 RSHD=0 CFRW=0 RSHG=40 RGO=15 RBULKO=234.5984 RWELLO=117.2992 RJUNSO=58.6496 RJUNDO=58.6496 SWSOA=0 VGS_MAX=3 VGD_MAX=3 VGB_MAX=3 VDS_MAX=3 VDB_MAX=1.6 VSB_MAX=1.6
model hvp_w34527n_l2000n_ng4 PSP103VA TYPE=-1 TR=27 DTA=0 SWGEO=1 SWIGATE=1 SWIMPACT=1 SWGIDL=1 SWJUNCAP=3 SWJUNASYM=0 SWNUD=0 SWEDGE=0 SWDELVTAC=0 SWIGN=1 QMC=1 LVARO=-1.735e-09 LVARL=0 LVARW=0 LAP=3.471e-08 WVARO=0 WVARL=0 WVARW=0 WOT=0 DLQ=3.537e-08 DWQ=3e-08 VFBO=-1.0717 VFBL=-0.03 VFBW=0 VFBLW=0 STVFBO=0.00057379 STVFBL=8.6794e-05 STVFBW=4.9309e-05 STVFBLW=-3.6436e-05 ST2VFBO=0 TOXO=6.945e-09 EPSROXO=3.9 NSUBO=4.2268e+23 NSUBW=0.01112 WSEG=5.362e-08 NPCK=8.0711e+23 NPCKW=-0.011403 WSEGP=1e-06 LPCK=8.3733e-09 LPCKW=0.077499 FOL1=0.065253 FOL2=0.010199 FACNEFFACO=1 FACNEFFACL=0 FACNEFFACW=0 FACNEFFACLW=0 GFACNUDO=1 GFACNUDL=0 GFACNUDLEXP=1 GFACNUDW=0 GFACNUDLW=0 VSBNUDO=0 DVSBNUDO=1 VNSUBO=0 NSLPO=0.05 DNSUBO=0.03585 DPHIBO=-0.077884807 DPHIBL=0.00526388544 DPHIBLEXP=2.1893 DPHIBW=-0.011141504 DPHIBLW=-9.3915789e-05 DELVTACO=0 DELVTACL=0 DELVTACLEXP=1 DELVTACW=0 DELVTACLW=0 NPO=1.092e+26 NPL=0.2188 TOXOVO=6.945e-09 TOXOVDO=2e-09 LOV=3.471e-08 LOVD=0 NOVO=1.99e+26 NOVDO=5e+25 CTO=-0.006328 CTL=0 CTLEXP=1 CTW=0.3006 CTLW=-0.01196 CTGO=0 CTBO=0 STCTO=1 CFL=0.00045884 CFLEXP=2.2055 CFW=0.45909 CFBO=1 CFDO=0 PSCEL=0 PSCELEXP=2 PSCEW=0 PSCEBO=0 PSCEDO=0 UO=0.018428 FBET1=0.15952 FBET1W=-2.1872 LP1=9.9822e-08 LP1W=-1.0871 FBET2=-2.7066 LP2=5.8401e-08 BETW1=-0.097534 BETW2=0.022314 WBET=7.9844e-10 STBETO=1.6489 STBETL=0.029528 STBETW=0.037078 STBETLW=0.046991 MUEO=1.7444601 MUEW=-0.06367 STMUEO=1.0816 THEMUO=1.0324 STTHEMUO=0.26337 CSO=0.18648 CSL=0.21903 CSLEXP=2.0917 CSW=0.0072837 CSLW=0.02 STCSO=2 THECSO=2 STTHECSO=0 XCORO=0.001363 XCORL=8 XCORW=0.0060537 XCORLW=0.058951 STXCORO=-6.939e-18 FETAO=1.2853 RSW1=1970 RSW2=-0.057547 STRSO=-0.24812 RSBO=0.074639 RSGO=0.23490984 THESATO=8.4917e-05 THESATL=0.0067396 THESATLEXP=2.395 THESATW=1.1549 THESATLW=-0.01 STTHESATO=3.0405 STTHESATL=-0.16001 STTHESATW=-0.96988 STTHESATLW=0.36213 THESATBO=0.1 THESATGO=0.6304 AXO=16.822 AXL=3.0092 ALPL=0.0058454 ALPLEXP=0.47562 ALPW=-0.065973 ALP1L1=4.4409e-16 ALP1LEXP=1.347 ALP1L2=1 ALP1W=2 ALP2L1=3.6779e-06 ALP2LEXP=0.2531 ALP2L2=2.2204e-15 ALP2W=0.9582 VPO=1.8436e-06 A1O=47.788 A1L=0.029145 A1W=0.01435 A2O=38.581 STA2O=-0.0049931 A3O=1.1753 A3L=-0.069795 A3W=0.0032538 A4O=0.12593 A4L=-0.07 A4W=-0.04811 GCOO=0 IGINVLW=0 IGOVW=0 IGOVDW=0 STIGO=2 GC2O=0.375 GC3O=0.063 CHIBO=3.1 AGIDLW=6e-10 AGIDLDW=0 BGIDLO=5.5970304 BGIDLDO=41 STBGIDLO=-0.0049461 STBGIDLDO=0 CGIDLO=0.23693 CGIDLDO=0 CGBOVL=-4.669e-16 CFRDW=0 FNTO=1 FNTEXCL=0 NFALW=1.3e+25 NFBLW=5289000000 NFCLW=2e-07 EFO=1.152 LINTNOI=2.5e-08 ALPNOI=2 WEDGE=1e-08 WEDGEW=0 VFBEDGEO=-1 STVFBEDGEO=0.0005 STVFBEDGEL=0 STVFBEDGEW=0 STVFBEDGELW=0 DPHIBEDGEO=0 DPHIBEDGEL=0 DPHIBEDGELEXP=1 DPHIBEDGEW=0 DPHIBEDGELW=0 NSUBEDGEO=5e+23 NSUBEDGEL=0 NSUBEDGELEXP=1 NSUBEDGEW=0 NSUBEDGELW=0 CTEDGEO=0 CTEDGEL=0 CTEDGELEXP=1 FBETEDGE=0 LPEDGE=1e-08 BETEDGEW=0 STBETEDGEO=1 STBETEDGEL=0 STBETEDGEW=0 STBETEDGELW=0 PSCEEDGEL=0 PSCEEDGELEXP=2 PSCEEDGEW=0 PSCEBEDGEO=0 PSCEDEDGEO=0 CFEDGEL=0 CFEDGELEXP=2 CFEDGEW=0 CFDEDGEO=0 CFBEDGEO=0 FNTEDGEO=1 NFAEDGELW=8e+22 NFBEDGELW=30000000 NFCEDGELW=0 EFEDGEO=1 SAREF=1e-06 SBREF=1e-06 WLOD=0 KUO=0 KVSAT=0 TKUO=0 LKUO=0 WKUO=0 PKUO=0 LLODKUO=0 WLODKUO=0 KVTHO=0 LKVTHO=0 WKVTHO=0 PKVTHO=0 LLODVTH=0 WLODVTH=0 STETAO=0 LODETAO=1 SCREF=1e-06 WEB=0 WEC=0 KVTHOWEO=0 KVTHOWEL=0 KVTHOWEW=0 KVTHOWELW=0 KUOWEO=0 KUOWEL=0 KUOWEW=0 KUOWELW=0 TRJ=21 SWJUNEXP=0 IMAX=0.0024527 FREV=1000 CJORBOT=0.0008095 CJORSTI=4.2583e-11 CJORGAT=3.1e-11 VBIRBOT=0.72606 VBIRSTI=0.69819 VBIRGAT=1.199 PBOT=0.33078 PSTI=0.22409 PGAT=0.4474 CJORBOTD=0.001 CJORSTID=1e-09 CJORGATD=1e-09 VBIRBOTD=1 VBIRSTID=1 VBIRGATD=1 PBOTD=0.5 PSTID=0.5 PGATD=0.5 PHIGBOT=1.0641 PHIGSTI=1.3946 PHIGGAT=1.83 IDSATRBOT=3.0606e-08 IDSATRSTI=3.6127e-15 IDSATRGAT=0 CSRHBOT=100 CSRHSTI=0.0001 CSRHGAT=0.0001 XJUNSTI=4.93e-08 XJUNGAT=7.062e-07 PHIGBOTD=1.16 PHIGSTID=1.16 PHIGGATD=1.16 IDSATRBOTD=1e-12 IDSATRSTID=1e-18 IDSATRGATD=1e-18 CSRHBOTD=100 CSRHSTID=0.0001 CSRHGATD=0.0001 XJUNSTID=1e-07 XJUNGATD=1e-07 CTATBOT=100 CTATSTI=0.0001 CTATGAT=0.0001 MEFFTATBOT=0.25 MEFFTATSTI=0.25 MEFFTATGAT=0.25 CTATBOTD=100 CTATSTID=0.0001 CTATGATD=0.0001 MEFFTATBOTD=0.25 MEFFTATSTID=0.25 MEFFTATGATD=0.25 CBBTBOT=1e-12 CBBTSTI=1e-21 CBBTGAT=1e-18 FBBTRBOT=1000000000 FBBTRSTI=1000000000 FBBTRGAT=1000000000 STFBBTBOT=-0.001 STFBBTSTI=-0.001 STFBBTGAT=-0.001 CBBTBOTD=1e-12 CBBTSTID=1e-18 CBBTGATD=1e-18 FBBTRBOTD=1000000000 FBBTRSTID=1000000000 FBBTRGATD=1000000000 STFBBTBOTD=-0.001 STFBBTSTID=-0.001 STFBBTGATD=-0.001 VBRBOT=10 VBRSTI=10 VBRGAT=10 PBRBOT=4 PBRSTI=4 PBRGAT=4 VBRBOTD=10 VBRSTID=10 VBRGATD=10 PBRBOTD=4 PBRSTID=4 PBRGATD=4 VJUNREF=2.5 FJUNQ=0.03 VJUNREFD=2.5 FJUNQD=0.03 RINT=0 RVPOLY=0 DLSIL=0 RSH=0 RSHD=0 CFRW=0 RSHG=40 RGO=15 RBULKO=231.7021235 RWELLO=115.8510617 RJUNSO=289.6276543 RJUNDO=289.6276543 SWSOA=0 VGS_MAX=3 VGD_MAX=3 VGB_MAX=3 VDS_MAX=3 VDB_MAX=1.6 VSB_MAX=1.6
model hvp_w4000n_l1000n_ng1 PSP103VA TYPE=-1 TR=27 DTA=0 SWGEO=1 SWIGATE=1 SWIMPACT=1 SWGIDL=1 SWJUNCAP=3 SWJUNASYM=0 SWNUD=0 SWEDGE=0 SWDELVTAC=0 SWIGN=1 QMC=1 LVARO=-1.735e-09 LVARL=0 LVARW=0 LAP=3.471e-08 WVARO=0 WVARL=0 WVARW=0 WOT=0 DLQ=3.537e-08 DWQ=3e-08 VFBO=-1.0717 VFBL=-0.03 VFBW=0 VFBLW=0 STVFBO=0.00057379 STVFBL=8.6794e-05 STVFBW=4.9309e-05 STVFBLW=-3.6436e-05 ST2VFBO=0 TOXO=6.945e-09 EPSROXO=3.9 NSUBO=4.2268e+23 NSUBW=0.01112 WSEG=5.362e-08 NPCK=8.0711e+23 NPCKW=-0.011403 WSEGP=1e-06 LPCK=8.3733e-09 LPCKW=0.077499 FOL1=0.065253 FOL2=0.010199 FACNEFFACO=1 FACNEFFACL=0 FACNEFFACW=0 FACNEFFACLW=0 GFACNUDO=1 GFACNUDL=0 GFACNUDLEXP=1 GFACNUDW=0 GFACNUDLW=0 VSBNUDO=0 DVSBNUDO=1 VNSUBO=0 NSLPO=0.05 DNSUBO=0.03585 DPHIBO=-0.077884807 DPHIBL=0.00526388544 DPHIBLEXP=2.1893 DPHIBW=-0.011141504 DPHIBLW=-9.3915789e-05 DELVTACO=0 DELVTACL=0 DELVTACLEXP=1 DELVTACW=0 DELVTACLW=0 NPO=1.092e+26 NPL=0.2188 TOXOVO=6.945e-09 TOXOVDO=2e-09 LOV=3.471e-08 LOVD=0 NOVO=1.99e+26 NOVDO=5e+25 CTO=-0.006328 CTL=0 CTLEXP=1 CTW=0.3006 CTLW=-0.01196 CTGO=0 CTBO=0 STCTO=1 CFL=0.00045884 CFLEXP=2.2055 CFW=0.45909 CFBO=1 CFDO=0 PSCEL=0 PSCELEXP=2 PSCEW=0 PSCEBO=0 PSCEDO=0 UO=0.018428 FBET1=0.15952 FBET1W=-2.1872 LP1=9.9822e-08 LP1W=-1.0871 FBET2=-2.7066 LP2=5.8401e-08 BETW1=-0.097534 BETW2=0.022314 WBET=7.9844e-10 STBETO=1.6489 STBETL=0.029528 STBETW=0.037078 STBETLW=0.046991 MUEO=1.7444601 MUEW=-0.06367 STMUEO=1.0816 THEMUO=1.0324 STTHEMUO=0.26337 CSO=0.18648 CSL=0.21903 CSLEXP=2.0917 CSW=0.0072837 CSLW=0.02 STCSO=2 THECSO=2 STTHECSO=0 XCORO=0.001363 XCORL=8 XCORW=0.0060537 XCORLW=0.058951 STXCORO=-6.939e-18 FETAO=1.2853 RSW1=1970 RSW2=-0.057547 STRSO=-0.24812 RSBO=0.074639 RSGO=0.23490984 THESATO=8.4917e-05 THESATL=0.0067396 THESATLEXP=2.395 THESATW=1.1549 THESATLW=-0.01 STTHESATO=3.0405 STTHESATL=-0.16001 STTHESATW=-0.96988 STTHESATLW=0.36213 THESATBO=0.1 THESATGO=0.6304 AXO=16.822 AXL=3.0092 ALPL=0.0058454 ALPLEXP=0.47562 ALPW=-0.065973 ALP1L1=4.4409e-16 ALP1LEXP=1.347 ALP1L2=1 ALP1W=2 ALP2L1=3.6779e-06 ALP2LEXP=0.2531 ALP2L2=2.2204e-15 ALP2W=0.9582 VPO=1.8436e-06 A1O=47.788 A1L=0.029145 A1W=0.01435 A2O=38.581 STA2O=-0.0049931 A3O=1.1753 A3L=-0.069795 A3W=0.0032538 A4O=0.12593 A4L=-0.07 A4W=-0.04811 GCOO=0 IGINVLW=0 IGOVW=0 IGOVDW=0 STIGO=2 GC2O=0.375 GC3O=0.063 CHIBO=3.1 AGIDLW=6e-10 AGIDLDW=0 BGIDLO=5.5970304 BGIDLDO=41 STBGIDLO=-0.0049461 STBGIDLDO=0 CGIDLO=0.23693 CGIDLDO=0 CGBOVL=-4.669e-16 CFRDW=0 FNTO=1 FNTEXCL=0 NFALW=1.3e+25 NFBLW=5289000000 NFCLW=2e-07 EFO=1.152 LINTNOI=2.5e-08 ALPNOI=2 WEDGE=1e-08 WEDGEW=0 VFBEDGEO=-1 STVFBEDGEO=0.0005 STVFBEDGEL=0 STVFBEDGEW=0 STVFBEDGELW=0 DPHIBEDGEO=0 DPHIBEDGEL=0 DPHIBEDGELEXP=1 DPHIBEDGEW=0 DPHIBEDGELW=0 NSUBEDGEO=5e+23 NSUBEDGEL=0 NSUBEDGELEXP=1 NSUBEDGEW=0 NSUBEDGELW=0 CTEDGEO=0 CTEDGEL=0 CTEDGELEXP=1 FBETEDGE=0 LPEDGE=1e-08 BETEDGEW=0 STBETEDGEO=1 STBETEDGEL=0 STBETEDGEW=0 STBETEDGELW=0 PSCEEDGEL=0 PSCEEDGELEXP=2 PSCEEDGEW=0 PSCEBEDGEO=0 PSCEDEDGEO=0 CFEDGEL=0 CFEDGELEXP=2 CFEDGEW=0 CFDEDGEO=0 CFBEDGEO=0 FNTEDGEO=1 NFAEDGELW=8e+22 NFBEDGELW=30000000 NFCEDGELW=0 EFEDGEO=1 SAREF=1e-06 SBREF=1e-06 WLOD=0 KUO=0 KVSAT=0 TKUO=0 LKUO=0 WKUO=0 PKUO=0 LLODKUO=0 WLODKUO=0 KVTHO=0 LKVTHO=0 WKVTHO=0 PKVTHO=0 LLODVTH=0 WLODVTH=0 STETAO=0 LODETAO=1 SCREF=1e-06 WEB=0 WEC=0 KVTHOWEO=0 KVTHOWEL=0 KVTHOWEW=0 KVTHOWELW=0 KUOWEO=0 KUOWEL=0 KUOWEW=0 KUOWELW=0 TRJ=21 SWJUNEXP=0 IMAX=0.0024527 FREV=1000 CJORBOT=0.0008095 CJORSTI=4.2583e-11 CJORGAT=3.1e-11 VBIRBOT=0.72606 VBIRSTI=0.69819 VBIRGAT=1.199 PBOT=0.33078 PSTI=0.22409 PGAT=0.4474 CJORBOTD=0.001 CJORSTID=1e-09 CJORGATD=1e-09 VBIRBOTD=1 VBIRSTID=1 VBIRGATD=1 PBOTD=0.5 PSTID=0.5 PGATD=0.5 PHIGBOT=1.0641 PHIGSTI=1.3946 PHIGGAT=1.83 IDSATRBOT=3.0606e-08 IDSATRSTI=3.6127e-15 IDSATRGAT=0 CSRHBOT=100 CSRHSTI=0.0001 CSRHGAT=0.0001 XJUNSTI=4.93e-08 XJUNGAT=7.062e-07 PHIGBOTD=1.16 PHIGSTID=1.16 PHIGGATD=1.16 IDSATRBOTD=1e-12 IDSATRSTID=1e-18 IDSATRGATD=1e-18 CSRHBOTD=100 CSRHSTID=0.0001 CSRHGATD=0.0001 XJUNSTID=1e-07 XJUNGATD=1e-07 CTATBOT=100 CTATSTI=0.0001 CTATGAT=0.0001 MEFFTATBOT=0.25 MEFFTATSTI=0.25 MEFFTATGAT=0.25 CTATBOTD=100 CTATSTID=0.0001 CTATGATD=0.0001 MEFFTATBOTD=0.25 MEFFTATSTID=0.25 MEFFTATGATD=0.25 CBBTBOT=1e-12 CBBTSTI=1e-21 CBBTGAT=1e-18 FBBTRBOT=1000000000 FBBTRSTI=1000000000 FBBTRGAT=1000000000 STFBBTBOT=-0.001 STFBBTSTI=-0.001 STFBBTGAT=-0.001 CBBTBOTD=1e-12 CBBTSTID=1e-18 CBBTGATD=1e-18 FBBTRBOTD=1000000000 FBBTRSTID=1000000000 FBBTRGATD=1000000000 STFBBTBOTD=-0.001 STFBBTSTID=-0.001 STFBBTGATD=-0.001 VBRBOT=10 VBRSTI=10 VBRGAT=10 PBRBOT=4 PBRSTI=4 PBRGAT=4 VBRBOTD=10 VBRSTID=10 VBRGATD=10 PBRBOTD=4 PBRSTID=4 PBRGATD=4 VJUNREF=2.5 FJUNQ=0.03 VJUNREFD=2.5 FJUNQD=0.03 RINT=0 RVPOLY=0 DLSIL=0 RSH=0 RSHD=0 CFRW=0 RSHG=40 RGO=15 RBULKO=500 RWELLO=250 RJUNSO=1250 RJUNDO=1250 SWSOA=0 VGS_MAX=3 VGD_MAX=3 VGB_MAX=3 VDS_MAX=3 VDB_MAX=1.6 VSB_MAX=1.6
model hvp_w4000n_l2000n_ng1 PSP103VA TYPE=-1 TR=27 DTA=0 SWGEO=1 SWIGATE=1 SWIMPACT=1 SWGIDL=1 SWJUNCAP=3 SWJUNASYM=0 SWNUD=0 SWEDGE=0 SWDELVTAC=0 SWIGN=1 QMC=1 LVARO=-1.735e-09 LVARL=0 LVARW=0 LAP=3.471e-08 WVARO=0 WVARL=0 WVARW=0 WOT=0 DLQ=3.537e-08 DWQ=3e-08 VFBO=-1.0717 VFBL=-0.03 VFBW=0 VFBLW=0 STVFBO=0.00057379 STVFBL=8.6794e-05 STVFBW=4.9309e-05 STVFBLW=-3.6436e-05 ST2VFBO=0 TOXO=6.945e-09 EPSROXO=3.9 NSUBO=4.2268e+23 NSUBW=0.01112 WSEG=5.362e-08 NPCK=8.0711e+23 NPCKW=-0.011403 WSEGP=1e-06 LPCK=8.3733e-09 LPCKW=0.077499 FOL1=0.065253 FOL2=0.010199 FACNEFFACO=1 FACNEFFACL=0 FACNEFFACW=0 FACNEFFACLW=0 GFACNUDO=1 GFACNUDL=0 GFACNUDLEXP=1 GFACNUDW=0 GFACNUDLW=0 VSBNUDO=0 DVSBNUDO=1 VNSUBO=0 NSLPO=0.05 DNSUBO=0.03585 DPHIBO=-0.077884807 DPHIBL=0.00526388544 DPHIBLEXP=2.1893 DPHIBW=-0.011141504 DPHIBLW=-9.3915789e-05 DELVTACO=0 DELVTACL=0 DELVTACLEXP=1 DELVTACW=0 DELVTACLW=0 NPO=1.092e+26 NPL=0.2188 TOXOVO=6.945e-09 TOXOVDO=2e-09 LOV=3.471e-08 LOVD=0 NOVO=1.99e+26 NOVDO=5e+25 CTO=-0.006328 CTL=0 CTLEXP=1 CTW=0.3006 CTLW=-0.01196 CTGO=0 CTBO=0 STCTO=1 CFL=0.00045884 CFLEXP=2.2055 CFW=0.45909 CFBO=1 CFDO=0 PSCEL=0 PSCELEXP=2 PSCEW=0 PSCEBO=0 PSCEDO=0 UO=0.018428 FBET1=0.15952 FBET1W=-2.1872 LP1=9.9822e-08 LP1W=-1.0871 FBET2=-2.7066 LP2=5.8401e-08 BETW1=-0.097534 BETW2=0.022314 WBET=7.9844e-10 STBETO=1.6489 STBETL=0.029528 STBETW=0.037078 STBETLW=0.046991 MUEO=1.7444601 MUEW=-0.06367 STMUEO=1.0816 THEMUO=1.0324 STTHEMUO=0.26337 CSO=0.18648 CSL=0.21903 CSLEXP=2.0917 CSW=0.0072837 CSLW=0.02 STCSO=2 THECSO=2 STTHECSO=0 XCORO=0.001363 XCORL=8 XCORW=0.0060537 XCORLW=0.058951 STXCORO=-6.939e-18 FETAO=1.2853 RSW1=1970 RSW2=-0.057547 STRSO=-0.24812 RSBO=0.074639 RSGO=0.23490984 THESATO=8.4917e-05 THESATL=0.0067396 THESATLEXP=2.395 THESATW=1.1549 THESATLW=-0.01 STTHESATO=3.0405 STTHESATL=-0.16001 STTHESATW=-0.96988 STTHESATLW=0.36213 THESATBO=0.1 THESATGO=0.6304 AXO=16.822 AXL=3.0092 ALPL=0.0058454 ALPLEXP=0.47562 ALPW=-0.065973 ALP1L1=4.4409e-16 ALP1LEXP=1.347 ALP1L2=1 ALP1W=2 ALP2L1=3.6779e-06 ALP2LEXP=0.2531 ALP2L2=2.2204e-15 ALP2W=0.9582 VPO=1.8436e-06 A1O=47.788 A1L=0.029145 A1W=0.01435 A2O=38.581 STA2O=-0.0049931 A3O=1.1753 A3L=-0.069795 A3W=0.0032538 A4O=0.12593 A4L=-0.07 A4W=-0.04811 GCOO=0 IGINVLW=0 IGOVW=0 IGOVDW=0 STIGO=2 GC2O=0.375 GC3O=0.063 CHIBO=3.1 AGIDLW=6e-10 AGIDLDW=0 BGIDLO=5.5970304 BGIDLDO=41 STBGIDLO=-0.0049461 STBGIDLDO=0 CGIDLO=0.23693 CGIDLDO=0 CGBOVL=-4.669e-16 CFRDW=0 FNTO=1 FNTEXCL=0 NFALW=1.3e+25 NFBLW=5289000000 NFCLW=2e-07 EFO=1.152 LINTNOI=2.5e-08 ALPNOI=2 WEDGE=1e-08 WEDGEW=0 VFBEDGEO=-1 STVFBEDGEO=0.0005 STVFBEDGEL=0 STVFBEDGEW=0 STVFBEDGELW=0 DPHIBEDGEO=0 DPHIBEDGEL=0 DPHIBEDGELEXP=1 DPHIBEDGEW=0 DPHIBEDGELW=0 NSUBEDGEO=5e+23 NSUBEDGEL=0 NSUBEDGELEXP=1 NSUBEDGEW=0 NSUBEDGELW=0 CTEDGEO=0 CTEDGEL=0 CTEDGELEXP=1 FBETEDGE=0 LPEDGE=1e-08 BETEDGEW=0 STBETEDGEO=1 STBETEDGEL=0 STBETEDGEW=0 STBETEDGELW=0 PSCEEDGEL=0 PSCEEDGELEXP=2 PSCEEDGEW=0 PSCEBEDGEO=0 PSCEDEDGEO=0 CFEDGEL=0 CFEDGELEXP=2 CFEDGEW=0 CFDEDGEO=0 CFBEDGEO=0 FNTEDGEO=1 NFAEDGELW=8e+22 NFBEDGELW=30000000 NFCEDGELW=0 EFEDGEO=1 SAREF=1e-06 SBREF=1e-06 WLOD=0 KUO=0 KVSAT=0 TKUO=0 LKUO=0 WKUO=0 PKUO=0 LLODKUO=0 WLODKUO=0 KVTHO=0 LKVTHO=0 WKVTHO=0 PKVTHO=0 LLODVTH=0 WLODVTH=0 STETAO=0 LODETAO=1 SCREF=1e-06 WEB=0 WEC=0 KVTHOWEO=0 KVTHOWEL=0 KVTHOWEW=0 KVTHOWELW=0 KUOWEO=0 KUOWEL=0 KUOWEW=0 KUOWELW=0 TRJ=21 SWJUNEXP=0 IMAX=0.0024527 FREV=1000 CJORBOT=0.0008095 CJORSTI=4.2583e-11 CJORGAT=3.1e-11 VBIRBOT=0.72606 VBIRSTI=0.69819 VBIRGAT=1.199 PBOT=0.33078 PSTI=0.22409 PGAT=0.4474 CJORBOTD=0.001 CJORSTID=1e-09 CJORGATD=1e-09 VBIRBOTD=1 VBIRSTID=1 VBIRGATD=1 PBOTD=0.5 PSTID=0.5 PGATD=0.5 PHIGBOT=1.0641 PHIGSTI=1.3946 PHIGGAT=1.83 IDSATRBOT=3.0606e-08 IDSATRSTI=3.6127e-15 IDSATRGAT=0 CSRHBOT=100 CSRHSTI=0.0001 CSRHGAT=0.0001 XJUNSTI=4.93e-08 XJUNGAT=7.062e-07 PHIGBOTD=1.16 PHIGSTID=1.16 PHIGGATD=1.16 IDSATRBOTD=1e-12 IDSATRSTID=1e-18 IDSATRGATD=1e-18 CSRHBOTD=100 CSRHSTID=0.0001 CSRHGATD=0.0001 XJUNSTID=1e-07 XJUNGATD=1e-07 CTATBOT=100 CTATSTI=0.0001 CTATGAT=0.0001 MEFFTATBOT=0.25 MEFFTATSTI=0.25 MEFFTATGAT=0.25 CTATBOTD=100 CTATSTID=0.0001 CTATGATD=0.0001 MEFFTATBOTD=0.25 MEFFTATSTID=0.25 MEFFTATGATD=0.25 CBBTBOT=1e-12 CBBTSTI=1e-21 CBBTGAT=1e-18 FBBTRBOT=1000000000 FBBTRSTI=1000000000 FBBTRGAT=1000000000 STFBBTBOT=-0.001 STFBBTSTI=-0.001 STFBBTGAT=-0.001 CBBTBOTD=1e-12 CBBTSTID=1e-18 CBBTGATD=1e-18 FBBTRBOTD=1000000000 FBBTRSTID=1000000000 FBBTRGATD=1000000000 STFBBTBOTD=-0.001 STFBBTSTID=-0.001 STFBBTGATD=-0.001 VBRBOT=10 VBRSTI=10 VBRGAT=10 PBRBOT=4 PBRSTI=4 PBRGAT=4 VBRBOTD=10 VBRSTID=10 VBRGATD=10 PBRBOTD=4 PBRSTID=4 PBRGATD=4 VJUNREF=2.5 FJUNQ=0.03 VJUNREFD=2.5 FJUNQD=0.03 RINT=0 RVPOLY=0 DLSIL=0 RSH=0 RSHD=0 CFRW=0 RSHG=40 RGO=15 RBULKO=500 RWELLO=250 RJUNSO=2500 RJUNDO=2500 SWSOA=0 VGS_MAX=3 VGD_MAX=3 VGB_MAX=3 VDS_MAX=3 VDB_MAX=1.6 VSB_MAX=1.6
model hvp_w4000n_l400n_ng1 PSP103VA TYPE=-1 TR=27 DTA=0 SWGEO=1 SWIGATE=1 SWIMPACT=1 SWGIDL=1 SWJUNCAP=3 SWJUNASYM=0 SWNUD=0 SWEDGE=0 SWDELVTAC=0 SWIGN=1 QMC=1 LVARO=-1.735e-09 LVARL=0 LVARW=0 LAP=3.471e-08 WVARO=0 WVARL=0 WVARW=0 WOT=0 DLQ=3.537e-08 DWQ=3e-08 VFBO=-1.0717 VFBL=-0.03 VFBW=0 VFBLW=0 STVFBO=0.00057379 STVFBL=8.6794e-05 STVFBW=4.9309e-05 STVFBLW=-3.6436e-05 ST2VFBO=0 TOXO=6.945e-09 EPSROXO=3.9 NSUBO=4.2268e+23 NSUBW=0.01112 WSEG=5.362e-08 NPCK=8.0711e+23 NPCKW=-0.011403 WSEGP=1e-06 LPCK=8.3733e-09 LPCKW=0.077499 FOL1=0.065253 FOL2=0.010199 FACNEFFACO=1 FACNEFFACL=0 FACNEFFACW=0 FACNEFFACLW=0 GFACNUDO=1 GFACNUDL=0 GFACNUDLEXP=1 GFACNUDW=0 GFACNUDLW=0 VSBNUDO=0 DVSBNUDO=1 VNSUBO=0 NSLPO=0.05 DNSUBO=0.03585 DPHIBO=-0.077884807 DPHIBL=0.00526388544 DPHIBLEXP=2.1893 DPHIBW=-0.011141504 DPHIBLW=-9.3915789e-05 DELVTACO=0 DELVTACL=0 DELVTACLEXP=1 DELVTACW=0 DELVTACLW=0 NPO=1.092e+26 NPL=0.2188 TOXOVO=6.945e-09 TOXOVDO=2e-09 LOV=3.471e-08 LOVD=0 NOVO=1.99e+26 NOVDO=5e+25 CTO=-0.006328 CTL=0 CTLEXP=1 CTW=0.3006 CTLW=-0.01196 CTGO=0 CTBO=0 STCTO=1 CFL=0.00045884 CFLEXP=2.2055 CFW=0.45909 CFBO=1 CFDO=0 PSCEL=0 PSCELEXP=2 PSCEW=0 PSCEBO=0 PSCEDO=0 UO=0.018428 FBET1=0.15952 FBET1W=-2.1872 LP1=9.9822e-08 LP1W=-1.0871 FBET2=-2.7066 LP2=5.8401e-08 BETW1=-0.097534 BETW2=0.022314 WBET=7.9844e-10 STBETO=1.6489 STBETL=0.029528 STBETW=0.037078 STBETLW=0.046991 MUEO=1.7444601 MUEW=-0.06367 STMUEO=1.0816 THEMUO=1.0324 STTHEMUO=0.26337 CSO=0.18648 CSL=0.21903 CSLEXP=2.0917 CSW=0.0072837 CSLW=0.02 STCSO=2 THECSO=2 STTHECSO=0 XCORO=0.001363 XCORL=8 XCORW=0.0060537 XCORLW=0.058951 STXCORO=-6.939e-18 FETAO=1.2853 RSW1=1970 RSW2=-0.057547 STRSO=-0.24812 RSBO=0.074639 RSGO=0.23490984 THESATO=8.4917e-05 THESATL=0.0067396 THESATLEXP=2.395 THESATW=1.1549 THESATLW=-0.01 STTHESATO=3.0405 STTHESATL=-0.16001 STTHESATW=-0.96988 STTHESATLW=0.36213 THESATBO=0.1 THESATGO=0.6304 AXO=16.822 AXL=3.0092 ALPL=0.0058454 ALPLEXP=0.47562 ALPW=-0.065973 ALP1L1=4.4409e-16 ALP1LEXP=1.347 ALP1L2=1 ALP1W=2 ALP2L1=3.6779e-06 ALP2LEXP=0.2531 ALP2L2=2.2204e-15 ALP2W=0.9582 VPO=1.8436e-06 A1O=47.788 A1L=0.029145 A1W=0.01435 A2O=38.581 STA2O=-0.0049931 A3O=1.1753 A3L=-0.069795 A3W=0.0032538 A4O=0.12593 A4L=-0.07 A4W=-0.04811 GCOO=0 IGINVLW=0 IGOVW=0 IGOVDW=0 STIGO=2 GC2O=0.375 GC3O=0.063 CHIBO=3.1 AGIDLW=6e-10 AGIDLDW=0 BGIDLO=5.5970304 BGIDLDO=41 STBGIDLO=-0.0049461 STBGIDLDO=0 CGIDLO=0.23693 CGIDLDO=0 CGBOVL=-4.669e-16 CFRDW=0 FNTO=1 FNTEXCL=0 NFALW=1.3e+25 NFBLW=5289000000 NFCLW=2e-07 EFO=1.152 LINTNOI=2.5e-08 ALPNOI=2 WEDGE=1e-08 WEDGEW=0 VFBEDGEO=-1 STVFBEDGEO=0.0005 STVFBEDGEL=0 STVFBEDGEW=0 STVFBEDGELW=0 DPHIBEDGEO=0 DPHIBEDGEL=0 DPHIBEDGELEXP=1 DPHIBEDGEW=0 DPHIBEDGELW=0 NSUBEDGEO=5e+23 NSUBEDGEL=0 NSUBEDGELEXP=1 NSUBEDGEW=0 NSUBEDGELW=0 CTEDGEO=0 CTEDGEL=0 CTEDGELEXP=1 FBETEDGE=0 LPEDGE=1e-08 BETEDGEW=0 STBETEDGEO=1 STBETEDGEL=0 STBETEDGEW=0 STBETEDGELW=0 PSCEEDGEL=0 PSCEEDGELEXP=2 PSCEEDGEW=0 PSCEBEDGEO=0 PSCEDEDGEO=0 CFEDGEL=0 CFEDGELEXP=2 CFEDGEW=0 CFDEDGEO=0 CFBEDGEO=0 FNTEDGEO=1 NFAEDGELW=8e+22 NFBEDGELW=30000000 NFCEDGELW=0 EFEDGEO=1 SAREF=1e-06 SBREF=1e-06 WLOD=0 KUO=0 KVSAT=0 TKUO=0 LKUO=0 WKUO=0 PKUO=0 LLODKUO=0 WLODKUO=0 KVTHO=0 LKVTHO=0 WKVTHO=0 PKVTHO=0 LLODVTH=0 WLODVTH=0 STETAO=0 LODETAO=1 SCREF=1e-06 WEB=0 WEC=0 KVTHOWEO=0 KVTHOWEL=0 KVTHOWEW=0 KVTHOWELW=0 KUOWEO=0 KUOWEL=0 KUOWEW=0 KUOWELW=0 TRJ=21 SWJUNEXP=0 IMAX=0.0024527 FREV=1000 CJORBOT=0.0008095 CJORSTI=4.2583e-11 CJORGAT=3.1e-11 VBIRBOT=0.72606 VBIRSTI=0.69819 VBIRGAT=1.199 PBOT=0.33078 PSTI=0.22409 PGAT=0.4474 CJORBOTD=0.001 CJORSTID=1e-09 CJORGATD=1e-09 VBIRBOTD=1 VBIRSTID=1 VBIRGATD=1 PBOTD=0.5 PSTID=0.5 PGATD=0.5 PHIGBOT=1.0641 PHIGSTI=1.3946 PHIGGAT=1.83 IDSATRBOT=3.0606e-08 IDSATRSTI=3.6127e-15 IDSATRGAT=0 CSRHBOT=100 CSRHSTI=0.0001 CSRHGAT=0.0001 XJUNSTI=4.93e-08 XJUNGAT=7.062e-07 PHIGBOTD=1.16 PHIGSTID=1.16 PHIGGATD=1.16 IDSATRBOTD=1e-12 IDSATRSTID=1e-18 IDSATRGATD=1e-18 CSRHBOTD=100 CSRHSTID=0.0001 CSRHGATD=0.0001 XJUNSTID=1e-07 XJUNGATD=1e-07 CTATBOT=100 CTATSTI=0.0001 CTATGAT=0.0001 MEFFTATBOT=0.25 MEFFTATSTI=0.25 MEFFTATGAT=0.25 CTATBOTD=100 CTATSTID=0.0001 CTATGATD=0.0001 MEFFTATBOTD=0.25 MEFFTATSTID=0.25 MEFFTATGATD=0.25 CBBTBOT=1e-12 CBBTSTI=1e-21 CBBTGAT=1e-18 FBBTRBOT=1000000000 FBBTRSTI=1000000000 FBBTRGAT=1000000000 STFBBTBOT=-0.001 STFBBTSTI=-0.001 STFBBTGAT=-0.001 CBBTBOTD=1e-12 CBBTSTID=1e-18 CBBTGATD=1e-18 FBBTRBOTD=1000000000 FBBTRSTID=1000000000 FBBTRGATD=1000000000 STFBBTBOTD=-0.001 STFBBTSTID=-0.001 STFBBTGATD=-0.001 VBRBOT=10 VBRSTI=10 VBRGAT=10 PBRBOT=4 PBRSTI=4 PBRGAT=4 VBRBOTD=10 VBRSTID=10 VBRGATD=10 PBRBOTD=4 PBRSTID=4 PBRGATD=4 VJUNREF=2.5 FJUNQ=0.03 VJUNREFD=2.5 FJUNQD=0.03 RINT=0 RVPOLY=0 DLSIL=0 RSH=0 RSHD=0 CFRW=0 RSHG=40 RGO=15 RBULKO=500 RWELLO=250 RJUNSO=500 RJUNDO=500 SWSOA=0 VGS_MAX=3 VGD_MAX=3 VGB_MAX=3 VDS_MAX=3 VDB_MAX=1.6 VSB_MAX=1.6
model hvp_w6892n_l400n_ng1 PSP103VA TYPE=-1 TR=27 DTA=0 SWGEO=1 SWIGATE=1 SWIMPACT=1 SWGIDL=1 SWJUNCAP=3 SWJUNASYM=0 SWNUD=0 SWEDGE=0 SWDELVTAC=0 SWIGN=1 QMC=1 LVARO=-1.735e-09 LVARL=0 LVARW=0 LAP=3.471e-08 WVARO=0 WVARL=0 WVARW=0 WOT=0 DLQ=3.537e-08 DWQ=3e-08 VFBO=-1.0717 VFBL=-0.03 VFBW=0 VFBLW=0 STVFBO=0.00057379 STVFBL=8.6794e-05 STVFBW=4.9309e-05 STVFBLW=-3.6436e-05 ST2VFBO=0 TOXO=6.945e-09 EPSROXO=3.9 NSUBO=4.2268e+23 NSUBW=0.01112 WSEG=5.362e-08 NPCK=8.0711e+23 NPCKW=-0.011403 WSEGP=1e-06 LPCK=8.3733e-09 LPCKW=0.077499 FOL1=0.065253 FOL2=0.010199 FACNEFFACO=1 FACNEFFACL=0 FACNEFFACW=0 FACNEFFACLW=0 GFACNUDO=1 GFACNUDL=0 GFACNUDLEXP=1 GFACNUDW=0 GFACNUDLW=0 VSBNUDO=0 DVSBNUDO=1 VNSUBO=0 NSLPO=0.05 DNSUBO=0.03585 DPHIBO=-0.077884807 DPHIBL=0.00526388544 DPHIBLEXP=2.1893 DPHIBW=-0.011141504 DPHIBLW=-9.3915789e-05 DELVTACO=0 DELVTACL=0 DELVTACLEXP=1 DELVTACW=0 DELVTACLW=0 NPO=1.092e+26 NPL=0.2188 TOXOVO=6.945e-09 TOXOVDO=2e-09 LOV=3.471e-08 LOVD=0 NOVO=1.99e+26 NOVDO=5e+25 CTO=-0.006328 CTL=0 CTLEXP=1 CTW=0.3006 CTLW=-0.01196 CTGO=0 CTBO=0 STCTO=1 CFL=0.00045884 CFLEXP=2.2055 CFW=0.45909 CFBO=1 CFDO=0 PSCEL=0 PSCELEXP=2 PSCEW=0 PSCEBO=0 PSCEDO=0 UO=0.018428 FBET1=0.15952 FBET1W=-2.1872 LP1=9.9822e-08 LP1W=-1.0871 FBET2=-2.7066 LP2=5.8401e-08 BETW1=-0.097534 BETW2=0.022314 WBET=7.9844e-10 STBETO=1.6489 STBETL=0.029528 STBETW=0.037078 STBETLW=0.046991 MUEO=1.7444601 MUEW=-0.06367 STMUEO=1.0816 THEMUO=1.0324 STTHEMUO=0.26337 CSO=0.18648 CSL=0.21903 CSLEXP=2.0917 CSW=0.0072837 CSLW=0.02 STCSO=2 THECSO=2 STTHECSO=0 XCORO=0.001363 XCORL=8 XCORW=0.0060537 XCORLW=0.058951 STXCORO=-6.939e-18 FETAO=1.2853 RSW1=1970 RSW2=-0.057547 STRSO=-0.24812 RSBO=0.074639 RSGO=0.23490984 THESATO=8.4917e-05 THESATL=0.0067396 THESATLEXP=2.395 THESATW=1.1549 THESATLW=-0.01 STTHESATO=3.0405 STTHESATL=-0.16001 STTHESATW=-0.96988 STTHESATLW=0.36213 THESATBO=0.1 THESATGO=0.6304 AXO=16.822 AXL=3.0092 ALPL=0.0058454 ALPLEXP=0.47562 ALPW=-0.065973 ALP1L1=4.4409e-16 ALP1LEXP=1.347 ALP1L2=1 ALP1W=2 ALP2L1=3.6779e-06 ALP2LEXP=0.2531 ALP2L2=2.2204e-15 ALP2W=0.9582 VPO=1.8436e-06 A1O=47.788 A1L=0.029145 A1W=0.01435 A2O=38.581 STA2O=-0.0049931 A3O=1.1753 A3L=-0.069795 A3W=0.0032538 A4O=0.12593 A4L=-0.07 A4W=-0.04811 GCOO=0 IGINVLW=0 IGOVW=0 IGOVDW=0 STIGO=2 GC2O=0.375 GC3O=0.063 CHIBO=3.1 AGIDLW=6e-10 AGIDLDW=0 BGIDLO=5.5970304 BGIDLDO=41 STBGIDLO=-0.0049461 STBGIDLDO=0 CGIDLO=0.23693 CGIDLDO=0 CGBOVL=-4.669e-16 CFRDW=0 FNTO=1 FNTEXCL=0 NFALW=1.3e+25 NFBLW=5289000000 NFCLW=2e-07 EFO=1.152 LINTNOI=2.5e-08 ALPNOI=2 WEDGE=1e-08 WEDGEW=0 VFBEDGEO=-1 STVFBEDGEO=0.0005 STVFBEDGEL=0 STVFBEDGEW=0 STVFBEDGELW=0 DPHIBEDGEO=0 DPHIBEDGEL=0 DPHIBEDGELEXP=1 DPHIBEDGEW=0 DPHIBEDGELW=0 NSUBEDGEO=5e+23 NSUBEDGEL=0 NSUBEDGELEXP=1 NSUBEDGEW=0 NSUBEDGELW=0 CTEDGEO=0 CTEDGEL=0 CTEDGELEXP=1 FBETEDGE=0 LPEDGE=1e-08 BETEDGEW=0 STBETEDGEO=1 STBETEDGEL=0 STBETEDGEW=0 STBETEDGELW=0 PSCEEDGEL=0 PSCEEDGELEXP=2 PSCEEDGEW=0 PSCEBEDGEO=0 PSCEDEDGEO=0 CFEDGEL=0 CFEDGELEXP=2 CFEDGEW=0 CFDEDGEO=0 CFBEDGEO=0 FNTEDGEO=1 NFAEDGELW=8e+22 NFBEDGELW=30000000 NFCEDGELW=0 EFEDGEO=1 SAREF=1e-06 SBREF=1e-06 WLOD=0 KUO=0 KVSAT=0 TKUO=0 LKUO=0 WKUO=0 PKUO=0 LLODKUO=0 WLODKUO=0 KVTHO=0 LKVTHO=0 WKVTHO=0 PKVTHO=0 LLODVTH=0 WLODVTH=0 STETAO=0 LODETAO=1 SCREF=1e-06 WEB=0 WEC=0 KVTHOWEO=0 KVTHOWEL=0 KVTHOWEW=0 KVTHOWELW=0 KUOWEO=0 KUOWEL=0 KUOWEW=0 KUOWELW=0 TRJ=21 SWJUNEXP=0 IMAX=0.0024527 FREV=1000 CJORBOT=0.0008095 CJORSTI=4.2583e-11 CJORGAT=3.1e-11 VBIRBOT=0.72606 VBIRSTI=0.69819 VBIRGAT=1.199 PBOT=0.33078 PSTI=0.22409 PGAT=0.4474 CJORBOTD=0.001 CJORSTID=1e-09 CJORGATD=1e-09 VBIRBOTD=1 VBIRSTID=1 VBIRGATD=1 PBOTD=0.5 PSTID=0.5 PGATD=0.5 PHIGBOT=1.0641 PHIGSTI=1.3946 PHIGGAT=1.83 IDSATRBOT=3.0606e-08 IDSATRSTI=3.6127e-15 IDSATRGAT=0 CSRHBOT=100 CSRHSTI=0.0001 CSRHGAT=0.0001 XJUNSTI=4.93e-08 XJUNGAT=7.062e-07 PHIGBOTD=1.16 PHIGSTID=1.16 PHIGGATD=1.16 IDSATRBOTD=1e-12 IDSATRSTID=1e-18 IDSATRGATD=1e-18 CSRHBOTD=100 CSRHSTID=0.0001 CSRHGATD=0.0001 XJUNSTID=1e-07 XJUNGATD=1e-07 CTATBOT=100 CTATSTI=0.0001 CTATGAT=0.0001 MEFFTATBOT=0.25 MEFFTATSTI=0.25 MEFFTATGAT=0.25 CTATBOTD=100 CTATSTID=0.0001 CTATGATD=0.0001 MEFFTATBOTD=0.25 MEFFTATSTID=0.25 MEFFTATGATD=0.25 CBBTBOT=1e-12 CBBTSTI=1e-21 CBBTGAT=1e-18 FBBTRBOT=1000000000 FBBTRSTI=1000000000 FBBTRGAT=1000000000 STFBBTBOT=-0.001 STFBBTSTI=-0.001 STFBBTGAT=-0.001 CBBTBOTD=1e-12 CBBTSTID=1e-18 CBBTGATD=1e-18 FBBTRBOTD=1000000000 FBBTRSTID=1000000000 FBBTRGATD=1000000000 STFBBTBOTD=-0.001 STFBBTSTID=-0.001 STFBBTGATD=-0.001 VBRBOT=10 VBRSTI=10 VBRGAT=10 PBRBOT=4 PBRSTI=4 PBRGAT=4 VBRBOTD=10 VBRSTID=10 VBRGATD=10 PBRBOTD=4 PBRSTID=4 PBRGATD=4 VJUNREF=2.5 FJUNQ=0.03 VJUNREFD=2.5 FJUNQD=0.03 RINT=0 RVPOLY=0 DLSIL=0 RSH=0 RSHD=0 CFRW=0 RSHG=40 RGO=15 RBULKO=290.1922685 RWELLO=145.0961342 RJUNSO=290.1922685 RJUNDO=290.1922685 SWSOA=0 VGS_MAX=3 VGD_MAX=3 VGB_MAX=3 VDS_MAX=3 VDB_MAX=1.6 VSB_MAX=1.6
model hvp_w7251n_l400n_ng1 PSP103VA TYPE=-1 TR=27 DTA=0 SWGEO=1 SWIGATE=1 SWIMPACT=1 SWGIDL=1 SWJUNCAP=3 SWJUNASYM=0 SWNUD=0 SWEDGE=0 SWDELVTAC=0 SWIGN=1 QMC=1 LVARO=-1.735e-09 LVARL=0 LVARW=0 LAP=3.471e-08 WVARO=0 WVARL=0 WVARW=0 WOT=0 DLQ=3.537e-08 DWQ=3e-08 VFBO=-1.0717 VFBL=-0.03 VFBW=0 VFBLW=0 STVFBO=0.00057379 STVFBL=8.6794e-05 STVFBW=4.9309e-05 STVFBLW=-3.6436e-05 ST2VFBO=0 TOXO=6.945e-09 EPSROXO=3.9 NSUBO=4.2268e+23 NSUBW=0.01112 WSEG=5.362e-08 NPCK=8.0711e+23 NPCKW=-0.011403 WSEGP=1e-06 LPCK=8.3733e-09 LPCKW=0.077499 FOL1=0.065253 FOL2=0.010199 FACNEFFACO=1 FACNEFFACL=0 FACNEFFACW=0 FACNEFFACLW=0 GFACNUDO=1 GFACNUDL=0 GFACNUDLEXP=1 GFACNUDW=0 GFACNUDLW=0 VSBNUDO=0 DVSBNUDO=1 VNSUBO=0 NSLPO=0.05 DNSUBO=0.03585 DPHIBO=-0.077884807 DPHIBL=0.00526388544 DPHIBLEXP=2.1893 DPHIBW=-0.011141504 DPHIBLW=-9.3915789e-05 DELVTACO=0 DELVTACL=0 DELVTACLEXP=1 DELVTACW=0 DELVTACLW=0 NPO=1.092e+26 NPL=0.2188 TOXOVO=6.945e-09 TOXOVDO=2e-09 LOV=3.471e-08 LOVD=0 NOVO=1.99e+26 NOVDO=5e+25 CTO=-0.006328 CTL=0 CTLEXP=1 CTW=0.3006 CTLW=-0.01196 CTGO=0 CTBO=0 STCTO=1 CFL=0.00045884 CFLEXP=2.2055 CFW=0.45909 CFBO=1 CFDO=0 PSCEL=0 PSCELEXP=2 PSCEW=0 PSCEBO=0 PSCEDO=0 UO=0.018428 FBET1=0.15952 FBET1W=-2.1872 LP1=9.9822e-08 LP1W=-1.0871 FBET2=-2.7066 LP2=5.8401e-08 BETW1=-0.097534 BETW2=0.022314 WBET=7.9844e-10 STBETO=1.6489 STBETL=0.029528 STBETW=0.037078 STBETLW=0.046991 MUEO=1.7444601 MUEW=-0.06367 STMUEO=1.0816 THEMUO=1.0324 STTHEMUO=0.26337 CSO=0.18648 CSL=0.21903 CSLEXP=2.0917 CSW=0.0072837 CSLW=0.02 STCSO=2 THECSO=2 STTHECSO=0 XCORO=0.001363 XCORL=8 XCORW=0.0060537 XCORLW=0.058951 STXCORO=-6.939e-18 FETAO=1.2853 RSW1=1970 RSW2=-0.057547 STRSO=-0.24812 RSBO=0.074639 RSGO=0.23490984 THESATO=8.4917e-05 THESATL=0.0067396 THESATLEXP=2.395 THESATW=1.1549 THESATLW=-0.01 STTHESATO=3.0405 STTHESATL=-0.16001 STTHESATW=-0.96988 STTHESATLW=0.36213 THESATBO=0.1 THESATGO=0.6304 AXO=16.822 AXL=3.0092 ALPL=0.0058454 ALPLEXP=0.47562 ALPW=-0.065973 ALP1L1=4.4409e-16 ALP1LEXP=1.347 ALP1L2=1 ALP1W=2 ALP2L1=3.6779e-06 ALP2LEXP=0.2531 ALP2L2=2.2204e-15 ALP2W=0.9582 VPO=1.8436e-06 A1O=47.788 A1L=0.029145 A1W=0.01435 A2O=38.581 STA2O=-0.0049931 A3O=1.1753 A3L=-0.069795 A3W=0.0032538 A4O=0.12593 A4L=-0.07 A4W=-0.04811 GCOO=0 IGINVLW=0 IGOVW=0 IGOVDW=0 STIGO=2 GC2O=0.375 GC3O=0.063 CHIBO=3.1 AGIDLW=6e-10 AGIDLDW=0 BGIDLO=5.5970304 BGIDLDO=41 STBGIDLO=-0.0049461 STBGIDLDO=0 CGIDLO=0.23693 CGIDLDO=0 CGBOVL=-4.669e-16 CFRDW=0 FNTO=1 FNTEXCL=0 NFALW=1.3e+25 NFBLW=5289000000 NFCLW=2e-07 EFO=1.152 LINTNOI=2.5e-08 ALPNOI=2 WEDGE=1e-08 WEDGEW=0 VFBEDGEO=-1 STVFBEDGEO=0.0005 STVFBEDGEL=0 STVFBEDGEW=0 STVFBEDGELW=0 DPHIBEDGEO=0 DPHIBEDGEL=0 DPHIBEDGELEXP=1 DPHIBEDGEW=0 DPHIBEDGELW=0 NSUBEDGEO=5e+23 NSUBEDGEL=0 NSUBEDGELEXP=1 NSUBEDGEW=0 NSUBEDGELW=0 CTEDGEO=0 CTEDGEL=0 CTEDGELEXP=1 FBETEDGE=0 LPEDGE=1e-08 BETEDGEW=0 STBETEDGEO=1 STBETEDGEL=0 STBETEDGEW=0 STBETEDGELW=0 PSCEEDGEL=0 PSCEEDGELEXP=2 PSCEEDGEW=0 PSCEBEDGEO=0 PSCEDEDGEO=0 CFEDGEL=0 CFEDGELEXP=2 CFEDGEW=0 CFDEDGEO=0 CFBEDGEO=0 FNTEDGEO=1 NFAEDGELW=8e+22 NFBEDGELW=30000000 NFCEDGELW=0 EFEDGEO=1 SAREF=1e-06 SBREF=1e-06 WLOD=0 KUO=0 KVSAT=0 TKUO=0 LKUO=0 WKUO=0 PKUO=0 LLODKUO=0 WLODKUO=0 KVTHO=0 LKVTHO=0 WKVTHO=0 PKVTHO=0 LLODVTH=0 WLODVTH=0 STETAO=0 LODETAO=1 SCREF=1e-06 WEB=0 WEC=0 KVTHOWEO=0 KVTHOWEL=0 KVTHOWEW=0 KVTHOWELW=0 KUOWEO=0 KUOWEL=0 KUOWEW=0 KUOWELW=0 TRJ=21 SWJUNEXP=0 IMAX=0.0024527 FREV=1000 CJORBOT=0.0008095 CJORSTI=4.2583e-11 CJORGAT=3.1e-11 VBIRBOT=0.72606 VBIRSTI=0.69819 VBIRGAT=1.199 PBOT=0.33078 PSTI=0.22409 PGAT=0.4474 CJORBOTD=0.001 CJORSTID=1e-09 CJORGATD=1e-09 VBIRBOTD=1 VBIRSTID=1 VBIRGATD=1 PBOTD=0.5 PSTID=0.5 PGATD=0.5 PHIGBOT=1.0641 PHIGSTI=1.3946 PHIGGAT=1.83 IDSATRBOT=3.0606e-08 IDSATRSTI=3.6127e-15 IDSATRGAT=0 CSRHBOT=100 CSRHSTI=0.0001 CSRHGAT=0.0001 XJUNSTI=4.93e-08 XJUNGAT=7.062e-07 PHIGBOTD=1.16 PHIGSTID=1.16 PHIGGATD=1.16 IDSATRBOTD=1e-12 IDSATRSTID=1e-18 IDSATRGATD=1e-18 CSRHBOTD=100 CSRHSTID=0.0001 CSRHGATD=0.0001 XJUNSTID=1e-07 XJUNGATD=1e-07 CTATBOT=100 CTATSTI=0.0001 CTATGAT=0.0001 MEFFTATBOT=0.25 MEFFTATSTI=0.25 MEFFTATGAT=0.25 CTATBOTD=100 CTATSTID=0.0001 CTATGATD=0.0001 MEFFTATBOTD=0.25 MEFFTATSTID=0.25 MEFFTATGATD=0.25 CBBTBOT=1e-12 CBBTSTI=1e-21 CBBTGAT=1e-18 FBBTRBOT=1000000000 FBBTRSTI=1000000000 FBBTRGAT=1000000000 STFBBTBOT=-0.001 STFBBTSTI=-0.001 STFBBTGAT=-0.001 CBBTBOTD=1e-12 CBBTSTID=1e-18 CBBTGATD=1e-18 FBBTRBOTD=1000000000 FBBTRSTID=1000000000 FBBTRGATD=1000000000 STFBBTBOTD=-0.001 STFBBTSTID=-0.001 STFBBTGATD=-0.001 VBRBOT=10 VBRSTI=10 VBRGAT=10 PBRBOT=4 PBRSTI=4 PBRGAT=4 VBRBOTD=10 VBRSTID=10 VBRGATD=10 PBRBOTD=4 PBRSTID=4 PBRGATD=4 VJUNREF=2.5 FJUNQ=0.03 VJUNREFD=2.5 FJUNQD=0.03 RINT=0 RVPOLY=0 DLSIL=0 RSH=0 RSHD=0 CFRW=0 RSHG=40 RGO=15 RBULKO=275.8259828 RWELLO=137.9129914 RJUNSO=275.8259828 RJUNDO=275.8259828 SWSOA=0 VGS_MAX=3 VGD_MAX=3 VGB_MAX=3 VDS_MAX=3 VDB_MAX=1.6 VSB_MAX=1.6
model hvp_w7545n_l400n_ng1 PSP103VA TYPE=-1 TR=27 DTA=0 SWGEO=1 SWIGATE=1 SWIMPACT=1 SWGIDL=1 SWJUNCAP=3 SWJUNASYM=0 SWNUD=0 SWEDGE=0 SWDELVTAC=0 SWIGN=1 QMC=1 LVARO=-1.735e-09 LVARL=0 LVARW=0 LAP=3.471e-08 WVARO=0 WVARL=0 WVARW=0 WOT=0 DLQ=3.537e-08 DWQ=3e-08 VFBO=-1.0717 VFBL=-0.03 VFBW=0 VFBLW=0 STVFBO=0.00057379 STVFBL=8.6794e-05 STVFBW=4.9309e-05 STVFBLW=-3.6436e-05 ST2VFBO=0 TOXO=6.945e-09 EPSROXO=3.9 NSUBO=4.2268e+23 NSUBW=0.01112 WSEG=5.362e-08 NPCK=8.0711e+23 NPCKW=-0.011403 WSEGP=1e-06 LPCK=8.3733e-09 LPCKW=0.077499 FOL1=0.065253 FOL2=0.010199 FACNEFFACO=1 FACNEFFACL=0 FACNEFFACW=0 FACNEFFACLW=0 GFACNUDO=1 GFACNUDL=0 GFACNUDLEXP=1 GFACNUDW=0 GFACNUDLW=0 VSBNUDO=0 DVSBNUDO=1 VNSUBO=0 NSLPO=0.05 DNSUBO=0.03585 DPHIBO=-0.077884807 DPHIBL=0.00526388544 DPHIBLEXP=2.1893 DPHIBW=-0.011141504 DPHIBLW=-9.3915789e-05 DELVTACO=0 DELVTACL=0 DELVTACLEXP=1 DELVTACW=0 DELVTACLW=0 NPO=1.092e+26 NPL=0.2188 TOXOVO=6.945e-09 TOXOVDO=2e-09 LOV=3.471e-08 LOVD=0 NOVO=1.99e+26 NOVDO=5e+25 CTO=-0.006328 CTL=0 CTLEXP=1 CTW=0.3006 CTLW=-0.01196 CTGO=0 CTBO=0 STCTO=1 CFL=0.00045884 CFLEXP=2.2055 CFW=0.45909 CFBO=1 CFDO=0 PSCEL=0 PSCELEXP=2 PSCEW=0 PSCEBO=0 PSCEDO=0 UO=0.018428 FBET1=0.15952 FBET1W=-2.1872 LP1=9.9822e-08 LP1W=-1.0871 FBET2=-2.7066 LP2=5.8401e-08 BETW1=-0.097534 BETW2=0.022314 WBET=7.9844e-10 STBETO=1.6489 STBETL=0.029528 STBETW=0.037078 STBETLW=0.046991 MUEO=1.7444601 MUEW=-0.06367 STMUEO=1.0816 THEMUO=1.0324 STTHEMUO=0.26337 CSO=0.18648 CSL=0.21903 CSLEXP=2.0917 CSW=0.0072837 CSLW=0.02 STCSO=2 THECSO=2 STTHECSO=0 XCORO=0.001363 XCORL=8 XCORW=0.0060537 XCORLW=0.058951 STXCORO=-6.939e-18 FETAO=1.2853 RSW1=1970 RSW2=-0.057547 STRSO=-0.24812 RSBO=0.074639 RSGO=0.23490984 THESATO=8.4917e-05 THESATL=0.0067396 THESATLEXP=2.395 THESATW=1.1549 THESATLW=-0.01 STTHESATO=3.0405 STTHESATL=-0.16001 STTHESATW=-0.96988 STTHESATLW=0.36213 THESATBO=0.1 THESATGO=0.6304 AXO=16.822 AXL=3.0092 ALPL=0.0058454 ALPLEXP=0.47562 ALPW=-0.065973 ALP1L1=4.4409e-16 ALP1LEXP=1.347 ALP1L2=1 ALP1W=2 ALP2L1=3.6779e-06 ALP2LEXP=0.2531 ALP2L2=2.2204e-15 ALP2W=0.9582 VPO=1.8436e-06 A1O=47.788 A1L=0.029145 A1W=0.01435 A2O=38.581 STA2O=-0.0049931 A3O=1.1753 A3L=-0.069795 A3W=0.0032538 A4O=0.12593 A4L=-0.07 A4W=-0.04811 GCOO=0 IGINVLW=0 IGOVW=0 IGOVDW=0 STIGO=2 GC2O=0.375 GC3O=0.063 CHIBO=3.1 AGIDLW=6e-10 AGIDLDW=0 BGIDLO=5.5970304 BGIDLDO=41 STBGIDLO=-0.0049461 STBGIDLDO=0 CGIDLO=0.23693 CGIDLDO=0 CGBOVL=-4.669e-16 CFRDW=0 FNTO=1 FNTEXCL=0 NFALW=1.3e+25 NFBLW=5289000000 NFCLW=2e-07 EFO=1.152 LINTNOI=2.5e-08 ALPNOI=2 WEDGE=1e-08 WEDGEW=0 VFBEDGEO=-1 STVFBEDGEO=0.0005 STVFBEDGEL=0 STVFBEDGEW=0 STVFBEDGELW=0 DPHIBEDGEO=0 DPHIBEDGEL=0 DPHIBEDGELEXP=1 DPHIBEDGEW=0 DPHIBEDGELW=0 NSUBEDGEO=5e+23 NSUBEDGEL=0 NSUBEDGELEXP=1 NSUBEDGEW=0 NSUBEDGELW=0 CTEDGEO=0 CTEDGEL=0 CTEDGELEXP=1 FBETEDGE=0 LPEDGE=1e-08 BETEDGEW=0 STBETEDGEO=1 STBETEDGEL=0 STBETEDGEW=0 STBETEDGELW=0 PSCEEDGEL=0 PSCEEDGELEXP=2 PSCEEDGEW=0 PSCEBEDGEO=0 PSCEDEDGEO=0 CFEDGEL=0 CFEDGELEXP=2 CFEDGEW=0 CFDEDGEO=0 CFBEDGEO=0 FNTEDGEO=1 NFAEDGELW=8e+22 NFBEDGELW=30000000 NFCEDGELW=0 EFEDGEO=1 SAREF=1e-06 SBREF=1e-06 WLOD=0 KUO=0 KVSAT=0 TKUO=0 LKUO=0 WKUO=0 PKUO=0 LLODKUO=0 WLODKUO=0 KVTHO=0 LKVTHO=0 WKVTHO=0 PKVTHO=0 LLODVTH=0 WLODVTH=0 STETAO=0 LODETAO=1 SCREF=1e-06 WEB=0 WEC=0 KVTHOWEO=0 KVTHOWEL=0 KVTHOWEW=0 KVTHOWELW=0 KUOWEO=0 KUOWEL=0 KUOWEW=0 KUOWELW=0 TRJ=21 SWJUNEXP=0 IMAX=0.0024527 FREV=1000 CJORBOT=0.0008095 CJORSTI=4.2583e-11 CJORGAT=3.1e-11 VBIRBOT=0.72606 VBIRSTI=0.69819 VBIRGAT=1.199 PBOT=0.33078 PSTI=0.22409 PGAT=0.4474 CJORBOTD=0.001 CJORSTID=1e-09 CJORGATD=1e-09 VBIRBOTD=1 VBIRSTID=1 VBIRGATD=1 PBOTD=0.5 PSTID=0.5 PGATD=0.5 PHIGBOT=1.0641 PHIGSTI=1.3946 PHIGGAT=1.83 IDSATRBOT=3.0606e-08 IDSATRSTI=3.6127e-15 IDSATRGAT=0 CSRHBOT=100 CSRHSTI=0.0001 CSRHGAT=0.0001 XJUNSTI=4.93e-08 XJUNGAT=7.062e-07 PHIGBOTD=1.16 PHIGSTID=1.16 PHIGGATD=1.16 IDSATRBOTD=1e-12 IDSATRSTID=1e-18 IDSATRGATD=1e-18 CSRHBOTD=100 CSRHSTID=0.0001 CSRHGATD=0.0001 XJUNSTID=1e-07 XJUNGATD=1e-07 CTATBOT=100 CTATSTI=0.0001 CTATGAT=0.0001 MEFFTATBOT=0.25 MEFFTATSTI=0.25 MEFFTATGAT=0.25 CTATBOTD=100 CTATSTID=0.0001 CTATGATD=0.0001 MEFFTATBOTD=0.25 MEFFTATSTID=0.25 MEFFTATGATD=0.25 CBBTBOT=1e-12 CBBTSTI=1e-21 CBBTGAT=1e-18 FBBTRBOT=1000000000 FBBTRSTI=1000000000 FBBTRGAT=1000000000 STFBBTBOT=-0.001 STFBBTSTI=-0.001 STFBBTGAT=-0.001 CBBTBOTD=1e-12 CBBTSTID=1e-18 CBBTGATD=1e-18 FBBTRBOTD=1000000000 FBBTRSTID=1000000000 FBBTRGATD=1000000000 STFBBTBOTD=-0.001 STFBBTSTID=-0.001 STFBBTGATD=-0.001 VBRBOT=10 VBRSTI=10 VBRGAT=10 PBRBOT=4 PBRSTI=4 PBRGAT=4 VBRBOTD=10 VBRSTID=10 VBRGATD=10 PBRBOTD=4 PBRSTID=4 PBRGATD=4 VJUNREF=2.5 FJUNQ=0.03 VJUNREFD=2.5 FJUNQD=0.03 RINT=0 RVPOLY=0 DLSIL=0 RSH=0 RSHD=0 CFRW=0 RSHG=40 RGO=15 RBULKO=265.0736435 RWELLO=132.5368217 RJUNSO=265.0736435 RJUNDO=265.0736435 SWSOA=0 VGS_MAX=3 VGD_MAX=3 VGB_MAX=3 VDS_MAX=3 VDB_MAX=1.6 VSB_MAX=1.6
model hvp_w8000n_l1000n_ng1 PSP103VA TYPE=-1 TR=27 DTA=0 SWGEO=1 SWIGATE=1 SWIMPACT=1 SWGIDL=1 SWJUNCAP=3 SWJUNASYM=0 SWNUD=0 SWEDGE=0 SWDELVTAC=0 SWIGN=1 QMC=1 LVARO=-1.735e-09 LVARL=0 LVARW=0 LAP=3.471e-08 WVARO=0 WVARL=0 WVARW=0 WOT=0 DLQ=3.537e-08 DWQ=3e-08 VFBO=-1.0717 VFBL=-0.03 VFBW=0 VFBLW=0 STVFBO=0.00057379 STVFBL=8.6794e-05 STVFBW=4.9309e-05 STVFBLW=-3.6436e-05 ST2VFBO=0 TOXO=6.945e-09 EPSROXO=3.9 NSUBO=4.2268e+23 NSUBW=0.01112 WSEG=5.362e-08 NPCK=8.0711e+23 NPCKW=-0.011403 WSEGP=1e-06 LPCK=8.3733e-09 LPCKW=0.077499 FOL1=0.065253 FOL2=0.010199 FACNEFFACO=1 FACNEFFACL=0 FACNEFFACW=0 FACNEFFACLW=0 GFACNUDO=1 GFACNUDL=0 GFACNUDLEXP=1 GFACNUDW=0 GFACNUDLW=0 VSBNUDO=0 DVSBNUDO=1 VNSUBO=0 NSLPO=0.05 DNSUBO=0.03585 DPHIBO=-0.077884807 DPHIBL=0.00526388544 DPHIBLEXP=2.1893 DPHIBW=-0.011141504 DPHIBLW=-9.3915789e-05 DELVTACO=0 DELVTACL=0 DELVTACLEXP=1 DELVTACW=0 DELVTACLW=0 NPO=1.092e+26 NPL=0.2188 TOXOVO=6.945e-09 TOXOVDO=2e-09 LOV=3.471e-08 LOVD=0 NOVO=1.99e+26 NOVDO=5e+25 CTO=-0.006328 CTL=0 CTLEXP=1 CTW=0.3006 CTLW=-0.01196 CTGO=0 CTBO=0 STCTO=1 CFL=0.00045884 CFLEXP=2.2055 CFW=0.45909 CFBO=1 CFDO=0 PSCEL=0 PSCELEXP=2 PSCEW=0 PSCEBO=0 PSCEDO=0 UO=0.018428 FBET1=0.15952 FBET1W=-2.1872 LP1=9.9822e-08 LP1W=-1.0871 FBET2=-2.7066 LP2=5.8401e-08 BETW1=-0.097534 BETW2=0.022314 WBET=7.9844e-10 STBETO=1.6489 STBETL=0.029528 STBETW=0.037078 STBETLW=0.046991 MUEO=1.7444601 MUEW=-0.06367 STMUEO=1.0816 THEMUO=1.0324 STTHEMUO=0.26337 CSO=0.18648 CSL=0.21903 CSLEXP=2.0917 CSW=0.0072837 CSLW=0.02 STCSO=2 THECSO=2 STTHECSO=0 XCORO=0.001363 XCORL=8 XCORW=0.0060537 XCORLW=0.058951 STXCORO=-6.939e-18 FETAO=1.2853 RSW1=1970 RSW2=-0.057547 STRSO=-0.24812 RSBO=0.074639 RSGO=0.23490984 THESATO=8.4917e-05 THESATL=0.0067396 THESATLEXP=2.395 THESATW=1.1549 THESATLW=-0.01 STTHESATO=3.0405 STTHESATL=-0.16001 STTHESATW=-0.96988 STTHESATLW=0.36213 THESATBO=0.1 THESATGO=0.6304 AXO=16.822 AXL=3.0092 ALPL=0.0058454 ALPLEXP=0.47562 ALPW=-0.065973 ALP1L1=4.4409e-16 ALP1LEXP=1.347 ALP1L2=1 ALP1W=2 ALP2L1=3.6779e-06 ALP2LEXP=0.2531 ALP2L2=2.2204e-15 ALP2W=0.9582 VPO=1.8436e-06 A1O=47.788 A1L=0.029145 A1W=0.01435 A2O=38.581 STA2O=-0.0049931 A3O=1.1753 A3L=-0.069795 A3W=0.0032538 A4O=0.12593 A4L=-0.07 A4W=-0.04811 GCOO=0 IGINVLW=0 IGOVW=0 IGOVDW=0 STIGO=2 GC2O=0.375 GC3O=0.063 CHIBO=3.1 AGIDLW=6e-10 AGIDLDW=0 BGIDLO=5.5970304 BGIDLDO=41 STBGIDLO=-0.0049461 STBGIDLDO=0 CGIDLO=0.23693 CGIDLDO=0 CGBOVL=-4.669e-16 CFRDW=0 FNTO=1 FNTEXCL=0 NFALW=1.3e+25 NFBLW=5289000000 NFCLW=2e-07 EFO=1.152 LINTNOI=2.5e-08 ALPNOI=2 WEDGE=1e-08 WEDGEW=0 VFBEDGEO=-1 STVFBEDGEO=0.0005 STVFBEDGEL=0 STVFBEDGEW=0 STVFBEDGELW=0 DPHIBEDGEO=0 DPHIBEDGEL=0 DPHIBEDGELEXP=1 DPHIBEDGEW=0 DPHIBEDGELW=0 NSUBEDGEO=5e+23 NSUBEDGEL=0 NSUBEDGELEXP=1 NSUBEDGEW=0 NSUBEDGELW=0 CTEDGEO=0 CTEDGEL=0 CTEDGELEXP=1 FBETEDGE=0 LPEDGE=1e-08 BETEDGEW=0 STBETEDGEO=1 STBETEDGEL=0 STBETEDGEW=0 STBETEDGELW=0 PSCEEDGEL=0 PSCEEDGELEXP=2 PSCEEDGEW=0 PSCEBEDGEO=0 PSCEDEDGEO=0 CFEDGEL=0 CFEDGELEXP=2 CFEDGEW=0 CFDEDGEO=0 CFBEDGEO=0 FNTEDGEO=1 NFAEDGELW=8e+22 NFBEDGELW=30000000 NFCEDGELW=0 EFEDGEO=1 SAREF=1e-06 SBREF=1e-06 WLOD=0 KUO=0 KVSAT=0 TKUO=0 LKUO=0 WKUO=0 PKUO=0 LLODKUO=0 WLODKUO=0 KVTHO=0 LKVTHO=0 WKVTHO=0 PKVTHO=0 LLODVTH=0 WLODVTH=0 STETAO=0 LODETAO=1 SCREF=1e-06 WEB=0 WEC=0 KVTHOWEO=0 KVTHOWEL=0 KVTHOWEW=0 KVTHOWELW=0 KUOWEO=0 KUOWEL=0 KUOWEW=0 KUOWELW=0 TRJ=21 SWJUNEXP=0 IMAX=0.0024527 FREV=1000 CJORBOT=0.0008095 CJORSTI=4.2583e-11 CJORGAT=3.1e-11 VBIRBOT=0.72606 VBIRSTI=0.69819 VBIRGAT=1.199 PBOT=0.33078 PSTI=0.22409 PGAT=0.4474 CJORBOTD=0.001 CJORSTID=1e-09 CJORGATD=1e-09 VBIRBOTD=1 VBIRSTID=1 VBIRGATD=1 PBOTD=0.5 PSTID=0.5 PGATD=0.5 PHIGBOT=1.0641 PHIGSTI=1.3946 PHIGGAT=1.83 IDSATRBOT=3.0606e-08 IDSATRSTI=3.6127e-15 IDSATRGAT=0 CSRHBOT=100 CSRHSTI=0.0001 CSRHGAT=0.0001 XJUNSTI=4.93e-08 XJUNGAT=7.062e-07 PHIGBOTD=1.16 PHIGSTID=1.16 PHIGGATD=1.16 IDSATRBOTD=1e-12 IDSATRSTID=1e-18 IDSATRGATD=1e-18 CSRHBOTD=100 CSRHSTID=0.0001 CSRHGATD=0.0001 XJUNSTID=1e-07 XJUNGATD=1e-07 CTATBOT=100 CTATSTI=0.0001 CTATGAT=0.0001 MEFFTATBOT=0.25 MEFFTATSTI=0.25 MEFFTATGAT=0.25 CTATBOTD=100 CTATSTID=0.0001 CTATGATD=0.0001 MEFFTATBOTD=0.25 MEFFTATSTID=0.25 MEFFTATGATD=0.25 CBBTBOT=1e-12 CBBTSTI=1e-21 CBBTGAT=1e-18 FBBTRBOT=1000000000 FBBTRSTI=1000000000 FBBTRGAT=1000000000 STFBBTBOT=-0.001 STFBBTSTI=-0.001 STFBBTGAT=-0.001 CBBTBOTD=1e-12 CBBTSTID=1e-18 CBBTGATD=1e-18 FBBTRBOTD=1000000000 FBBTRSTID=1000000000 FBBTRGATD=1000000000 STFBBTBOTD=-0.001 STFBBTSTID=-0.001 STFBBTGATD=-0.001 VBRBOT=10 VBRSTI=10 VBRGAT=10 PBRBOT=4 PBRSTI=4 PBRGAT=4 VBRBOTD=10 VBRSTID=10 VBRGATD=10 PBRBOTD=4 PBRSTID=4 PBRGATD=4 VJUNREF=2.5 FJUNQ=0.03 VJUNREFD=2.5 FJUNQD=0.03 RINT=0 RVPOLY=0 DLSIL=0 RSH=0 RSHD=0 CFRW=0 RSHG=40 RGO=15 RBULKO=250 RWELLO=125 RJUNSO=625 RJUNDO=625 SWSOA=0 VGS_MAX=3 VGD_MAX=3 VGB_MAX=3 VDS_MAX=3 VDB_MAX=1.6 VSB_MAX=1.6
model hvp_w8000n_l2000n_ng1 PSP103VA TYPE=-1 TR=27 DTA=0 SWGEO=1 SWIGATE=1 SWIMPACT=1 SWGIDL=1 SWJUNCAP=3 SWJUNASYM=0 SWNUD=0 SWEDGE=0 SWDELVTAC=0 SWIGN=1 QMC=1 LVARO=-1.735e-09 LVARL=0 LVARW=0 LAP=3.471e-08 WVARO=0 WVARL=0 WVARW=0 WOT=0 DLQ=3.537e-08 DWQ=3e-08 VFBO=-1.0717 VFBL=-0.03 VFBW=0 VFBLW=0 STVFBO=0.00057379 STVFBL=8.6794e-05 STVFBW=4.9309e-05 STVFBLW=-3.6436e-05 ST2VFBO=0 TOXO=6.945e-09 EPSROXO=3.9 NSUBO=4.2268e+23 NSUBW=0.01112 WSEG=5.362e-08 NPCK=8.0711e+23 NPCKW=-0.011403 WSEGP=1e-06 LPCK=8.3733e-09 LPCKW=0.077499 FOL1=0.065253 FOL2=0.010199 FACNEFFACO=1 FACNEFFACL=0 FACNEFFACW=0 FACNEFFACLW=0 GFACNUDO=1 GFACNUDL=0 GFACNUDLEXP=1 GFACNUDW=0 GFACNUDLW=0 VSBNUDO=0 DVSBNUDO=1 VNSUBO=0 NSLPO=0.05 DNSUBO=0.03585 DPHIBO=-0.077884807 DPHIBL=0.00526388544 DPHIBLEXP=2.1893 DPHIBW=-0.011141504 DPHIBLW=-9.3915789e-05 DELVTACO=0 DELVTACL=0 DELVTACLEXP=1 DELVTACW=0 DELVTACLW=0 NPO=1.092e+26 NPL=0.2188 TOXOVO=6.945e-09 TOXOVDO=2e-09 LOV=3.471e-08 LOVD=0 NOVO=1.99e+26 NOVDO=5e+25 CTO=-0.006328 CTL=0 CTLEXP=1 CTW=0.3006 CTLW=-0.01196 CTGO=0 CTBO=0 STCTO=1 CFL=0.00045884 CFLEXP=2.2055 CFW=0.45909 CFBO=1 CFDO=0 PSCEL=0 PSCELEXP=2 PSCEW=0 PSCEBO=0 PSCEDO=0 UO=0.018428 FBET1=0.15952 FBET1W=-2.1872 LP1=9.9822e-08 LP1W=-1.0871 FBET2=-2.7066 LP2=5.8401e-08 BETW1=-0.097534 BETW2=0.022314 WBET=7.9844e-10 STBETO=1.6489 STBETL=0.029528 STBETW=0.037078 STBETLW=0.046991 MUEO=1.7444601 MUEW=-0.06367 STMUEO=1.0816 THEMUO=1.0324 STTHEMUO=0.26337 CSO=0.18648 CSL=0.21903 CSLEXP=2.0917 CSW=0.0072837 CSLW=0.02 STCSO=2 THECSO=2 STTHECSO=0 XCORO=0.001363 XCORL=8 XCORW=0.0060537 XCORLW=0.058951 STXCORO=-6.939e-18 FETAO=1.2853 RSW1=1970 RSW2=-0.057547 STRSO=-0.24812 RSBO=0.074639 RSGO=0.23490984 THESATO=8.4917e-05 THESATL=0.0067396 THESATLEXP=2.395 THESATW=1.1549 THESATLW=-0.01 STTHESATO=3.0405 STTHESATL=-0.16001 STTHESATW=-0.96988 STTHESATLW=0.36213 THESATBO=0.1 THESATGO=0.6304 AXO=16.822 AXL=3.0092 ALPL=0.0058454 ALPLEXP=0.47562 ALPW=-0.065973 ALP1L1=4.4409e-16 ALP1LEXP=1.347 ALP1L2=1 ALP1W=2 ALP2L1=3.6779e-06 ALP2LEXP=0.2531 ALP2L2=2.2204e-15 ALP2W=0.9582 VPO=1.8436e-06 A1O=47.788 A1L=0.029145 A1W=0.01435 A2O=38.581 STA2O=-0.0049931 A3O=1.1753 A3L=-0.069795 A3W=0.0032538 A4O=0.12593 A4L=-0.07 A4W=-0.04811 GCOO=0 IGINVLW=0 IGOVW=0 IGOVDW=0 STIGO=2 GC2O=0.375 GC3O=0.063 CHIBO=3.1 AGIDLW=6e-10 AGIDLDW=0 BGIDLO=5.5970304 BGIDLDO=41 STBGIDLO=-0.0049461 STBGIDLDO=0 CGIDLO=0.23693 CGIDLDO=0 CGBOVL=-4.669e-16 CFRDW=0 FNTO=1 FNTEXCL=0 NFALW=1.3e+25 NFBLW=5289000000 NFCLW=2e-07 EFO=1.152 LINTNOI=2.5e-08 ALPNOI=2 WEDGE=1e-08 WEDGEW=0 VFBEDGEO=-1 STVFBEDGEO=0.0005 STVFBEDGEL=0 STVFBEDGEW=0 STVFBEDGELW=0 DPHIBEDGEO=0 DPHIBEDGEL=0 DPHIBEDGELEXP=1 DPHIBEDGEW=0 DPHIBEDGELW=0 NSUBEDGEO=5e+23 NSUBEDGEL=0 NSUBEDGELEXP=1 NSUBEDGEW=0 NSUBEDGELW=0 CTEDGEO=0 CTEDGEL=0 CTEDGELEXP=1 FBETEDGE=0 LPEDGE=1e-08 BETEDGEW=0 STBETEDGEO=1 STBETEDGEL=0 STBETEDGEW=0 STBETEDGELW=0 PSCEEDGEL=0 PSCEEDGELEXP=2 PSCEEDGEW=0 PSCEBEDGEO=0 PSCEDEDGEO=0 CFEDGEL=0 CFEDGELEXP=2 CFEDGEW=0 CFDEDGEO=0 CFBEDGEO=0 FNTEDGEO=1 NFAEDGELW=8e+22 NFBEDGELW=30000000 NFCEDGELW=0 EFEDGEO=1 SAREF=1e-06 SBREF=1e-06 WLOD=0 KUO=0 KVSAT=0 TKUO=0 LKUO=0 WKUO=0 PKUO=0 LLODKUO=0 WLODKUO=0 KVTHO=0 LKVTHO=0 WKVTHO=0 PKVTHO=0 LLODVTH=0 WLODVTH=0 STETAO=0 LODETAO=1 SCREF=1e-06 WEB=0 WEC=0 KVTHOWEO=0 KVTHOWEL=0 KVTHOWEW=0 KVTHOWELW=0 KUOWEO=0 KUOWEL=0 KUOWEW=0 KUOWELW=0 TRJ=21 SWJUNEXP=0 IMAX=0.0024527 FREV=1000 CJORBOT=0.0008095 CJORSTI=4.2583e-11 CJORGAT=3.1e-11 VBIRBOT=0.72606 VBIRSTI=0.69819 VBIRGAT=1.199 PBOT=0.33078 PSTI=0.22409 PGAT=0.4474 CJORBOTD=0.001 CJORSTID=1e-09 CJORGATD=1e-09 VBIRBOTD=1 VBIRSTID=1 VBIRGATD=1 PBOTD=0.5 PSTID=0.5 PGATD=0.5 PHIGBOT=1.0641 PHIGSTI=1.3946 PHIGGAT=1.83 IDSATRBOT=3.0606e-08 IDSATRSTI=3.6127e-15 IDSATRGAT=0 CSRHBOT=100 CSRHSTI=0.0001 CSRHGAT=0.0001 XJUNSTI=4.93e-08 XJUNGAT=7.062e-07 PHIGBOTD=1.16 PHIGSTID=1.16 PHIGGATD=1.16 IDSATRBOTD=1e-12 IDSATRSTID=1e-18 IDSATRGATD=1e-18 CSRHBOTD=100 CSRHSTID=0.0001 CSRHGATD=0.0001 XJUNSTID=1e-07 XJUNGATD=1e-07 CTATBOT=100 CTATSTI=0.0001 CTATGAT=0.0001 MEFFTATBOT=0.25 MEFFTATSTI=0.25 MEFFTATGAT=0.25 CTATBOTD=100 CTATSTID=0.0001 CTATGATD=0.0001 MEFFTATBOTD=0.25 MEFFTATSTID=0.25 MEFFTATGATD=0.25 CBBTBOT=1e-12 CBBTSTI=1e-21 CBBTGAT=1e-18 FBBTRBOT=1000000000 FBBTRSTI=1000000000 FBBTRGAT=1000000000 STFBBTBOT=-0.001 STFBBTSTI=-0.001 STFBBTGAT=-0.001 CBBTBOTD=1e-12 CBBTSTID=1e-18 CBBTGATD=1e-18 FBBTRBOTD=1000000000 FBBTRSTID=1000000000 FBBTRGATD=1000000000 STFBBTBOTD=-0.001 STFBBTSTID=-0.001 STFBBTGATD=-0.001 VBRBOT=10 VBRSTI=10 VBRGAT=10 PBRBOT=4 PBRSTI=4 PBRGAT=4 VBRBOTD=10 VBRSTID=10 VBRGATD=10 PBRBOTD=4 PBRSTID=4 PBRGATD=4 VJUNREF=2.5 FJUNQ=0.03 VJUNREFD=2.5 FJUNQD=0.03 RINT=0 RVPOLY=0 DLSIL=0 RSH=0 RSHD=0 CFRW=0 RSHG=40 RGO=15 RBULKO=250 RWELLO=125 RJUNSO=1250 RJUNDO=1250 SWSOA=0 VGS_MAX=3 VGD_MAX=3 VGB_MAX=3 VDS_MAX=3 VDB_MAX=1.6 VSB_MAX=1.6
model hvp_w8000n_l400n_ng1 PSP103VA TYPE=-1 TR=27 DTA=0 SWGEO=1 SWIGATE=1 SWIMPACT=1 SWGIDL=1 SWJUNCAP=3 SWJUNASYM=0 SWNUD=0 SWEDGE=0 SWDELVTAC=0 SWIGN=1 QMC=1 LVARO=-1.735e-09 LVARL=0 LVARW=0 LAP=3.471e-08 WVARO=0 WVARL=0 WVARW=0 WOT=0 DLQ=3.537e-08 DWQ=3e-08 VFBO=-1.0717 VFBL=-0.03 VFBW=0 VFBLW=0 STVFBO=0.00057379 STVFBL=8.6794e-05 STVFBW=4.9309e-05 STVFBLW=-3.6436e-05 ST2VFBO=0 TOXO=6.945e-09 EPSROXO=3.9 NSUBO=4.2268e+23 NSUBW=0.01112 WSEG=5.362e-08 NPCK=8.0711e+23 NPCKW=-0.011403 WSEGP=1e-06 LPCK=8.3733e-09 LPCKW=0.077499 FOL1=0.065253 FOL2=0.010199 FACNEFFACO=1 FACNEFFACL=0 FACNEFFACW=0 FACNEFFACLW=0 GFACNUDO=1 GFACNUDL=0 GFACNUDLEXP=1 GFACNUDW=0 GFACNUDLW=0 VSBNUDO=0 DVSBNUDO=1 VNSUBO=0 NSLPO=0.05 DNSUBO=0.03585 DPHIBO=-0.077884807 DPHIBL=0.00526388544 DPHIBLEXP=2.1893 DPHIBW=-0.011141504 DPHIBLW=-9.3915789e-05 DELVTACO=0 DELVTACL=0 DELVTACLEXP=1 DELVTACW=0 DELVTACLW=0 NPO=1.092e+26 NPL=0.2188 TOXOVO=6.945e-09 TOXOVDO=2e-09 LOV=3.471e-08 LOVD=0 NOVO=1.99e+26 NOVDO=5e+25 CTO=-0.006328 CTL=0 CTLEXP=1 CTW=0.3006 CTLW=-0.01196 CTGO=0 CTBO=0 STCTO=1 CFL=0.00045884 CFLEXP=2.2055 CFW=0.45909 CFBO=1 CFDO=0 PSCEL=0 PSCELEXP=2 PSCEW=0 PSCEBO=0 PSCEDO=0 UO=0.018428 FBET1=0.15952 FBET1W=-2.1872 LP1=9.9822e-08 LP1W=-1.0871 FBET2=-2.7066 LP2=5.8401e-08 BETW1=-0.097534 BETW2=0.022314 WBET=7.9844e-10 STBETO=1.6489 STBETL=0.029528 STBETW=0.037078 STBETLW=0.046991 MUEO=1.7444601 MUEW=-0.06367 STMUEO=1.0816 THEMUO=1.0324 STTHEMUO=0.26337 CSO=0.18648 CSL=0.21903 CSLEXP=2.0917 CSW=0.0072837 CSLW=0.02 STCSO=2 THECSO=2 STTHECSO=0 XCORO=0.001363 XCORL=8 XCORW=0.0060537 XCORLW=0.058951 STXCORO=-6.939e-18 FETAO=1.2853 RSW1=1970 RSW2=-0.057547 STRSO=-0.24812 RSBO=0.074639 RSGO=0.23490984 THESATO=8.4917e-05 THESATL=0.0067396 THESATLEXP=2.395 THESATW=1.1549 THESATLW=-0.01 STTHESATO=3.0405 STTHESATL=-0.16001 STTHESATW=-0.96988 STTHESATLW=0.36213 THESATBO=0.1 THESATGO=0.6304 AXO=16.822 AXL=3.0092 ALPL=0.0058454 ALPLEXP=0.47562 ALPW=-0.065973 ALP1L1=4.4409e-16 ALP1LEXP=1.347 ALP1L2=1 ALP1W=2 ALP2L1=3.6779e-06 ALP2LEXP=0.2531 ALP2L2=2.2204e-15 ALP2W=0.9582 VPO=1.8436e-06 A1O=47.788 A1L=0.029145 A1W=0.01435 A2O=38.581 STA2O=-0.0049931 A3O=1.1753 A3L=-0.069795 A3W=0.0032538 A4O=0.12593 A4L=-0.07 A4W=-0.04811 GCOO=0 IGINVLW=0 IGOVW=0 IGOVDW=0 STIGO=2 GC2O=0.375 GC3O=0.063 CHIBO=3.1 AGIDLW=6e-10 AGIDLDW=0 BGIDLO=5.5970304 BGIDLDO=41 STBGIDLO=-0.0049461 STBGIDLDO=0 CGIDLO=0.23693 CGIDLDO=0 CGBOVL=-4.669e-16 CFRDW=0 FNTO=1 FNTEXCL=0 NFALW=1.3e+25 NFBLW=5289000000 NFCLW=2e-07 EFO=1.152 LINTNOI=2.5e-08 ALPNOI=2 WEDGE=1e-08 WEDGEW=0 VFBEDGEO=-1 STVFBEDGEO=0.0005 STVFBEDGEL=0 STVFBEDGEW=0 STVFBEDGELW=0 DPHIBEDGEO=0 DPHIBEDGEL=0 DPHIBEDGELEXP=1 DPHIBEDGEW=0 DPHIBEDGELW=0 NSUBEDGEO=5e+23 NSUBEDGEL=0 NSUBEDGELEXP=1 NSUBEDGEW=0 NSUBEDGELW=0 CTEDGEO=0 CTEDGEL=0 CTEDGELEXP=1 FBETEDGE=0 LPEDGE=1e-08 BETEDGEW=0 STBETEDGEO=1 STBETEDGEL=0 STBETEDGEW=0 STBETEDGELW=0 PSCEEDGEL=0 PSCEEDGELEXP=2 PSCEEDGEW=0 PSCEBEDGEO=0 PSCEDEDGEO=0 CFEDGEL=0 CFEDGELEXP=2 CFEDGEW=0 CFDEDGEO=0 CFBEDGEO=0 FNTEDGEO=1 NFAEDGELW=8e+22 NFBEDGELW=30000000 NFCEDGELW=0 EFEDGEO=1 SAREF=1e-06 SBREF=1e-06 WLOD=0 KUO=0 KVSAT=0 TKUO=0 LKUO=0 WKUO=0 PKUO=0 LLODKUO=0 WLODKUO=0 KVTHO=0 LKVTHO=0 WKVTHO=0 PKVTHO=0 LLODVTH=0 WLODVTH=0 STETAO=0 LODETAO=1 SCREF=1e-06 WEB=0 WEC=0 KVTHOWEO=0 KVTHOWEL=0 KVTHOWEW=0 KVTHOWELW=0 KUOWEO=0 KUOWEL=0 KUOWEW=0 KUOWELW=0 TRJ=21 SWJUNEXP=0 IMAX=0.0024527 FREV=1000 CJORBOT=0.0008095 CJORSTI=4.2583e-11 CJORGAT=3.1e-11 VBIRBOT=0.72606 VBIRSTI=0.69819 VBIRGAT=1.199 PBOT=0.33078 PSTI=0.22409 PGAT=0.4474 CJORBOTD=0.001 CJORSTID=1e-09 CJORGATD=1e-09 VBIRBOTD=1 VBIRSTID=1 VBIRGATD=1 PBOTD=0.5 PSTID=0.5 PGATD=0.5 PHIGBOT=1.0641 PHIGSTI=1.3946 PHIGGAT=1.83 IDSATRBOT=3.0606e-08 IDSATRSTI=3.6127e-15 IDSATRGAT=0 CSRHBOT=100 CSRHSTI=0.0001 CSRHGAT=0.0001 XJUNSTI=4.93e-08 XJUNGAT=7.062e-07 PHIGBOTD=1.16 PHIGSTID=1.16 PHIGGATD=1.16 IDSATRBOTD=1e-12 IDSATRSTID=1e-18 IDSATRGATD=1e-18 CSRHBOTD=100 CSRHSTID=0.0001 CSRHGATD=0.0001 XJUNSTID=1e-07 XJUNGATD=1e-07 CTATBOT=100 CTATSTI=0.0001 CTATGAT=0.0001 MEFFTATBOT=0.25 MEFFTATSTI=0.25 MEFFTATGAT=0.25 CTATBOTD=100 CTATSTID=0.0001 CTATGATD=0.0001 MEFFTATBOTD=0.25 MEFFTATSTID=0.25 MEFFTATGATD=0.25 CBBTBOT=1e-12 CBBTSTI=1e-21 CBBTGAT=1e-18 FBBTRBOT=1000000000 FBBTRSTI=1000000000 FBBTRGAT=1000000000 STFBBTBOT=-0.001 STFBBTSTI=-0.001 STFBBTGAT=-0.001 CBBTBOTD=1e-12 CBBTSTID=1e-18 CBBTGATD=1e-18 FBBTRBOTD=1000000000 FBBTRSTID=1000000000 FBBTRGATD=1000000000 STFBBTBOTD=-0.001 STFBBTSTID=-0.001 STFBBTGATD=-0.001 VBRBOT=10 VBRSTI=10 VBRGAT=10 PBRBOT=4 PBRSTI=4 PBRGAT=4 VBRBOTD=10 VBRSTID=10 VBRGATD=10 PBRBOTD=4 PBRSTID=4 PBRGATD=4 VJUNREF=2.5 FJUNQ=0.03 VJUNREFD=2.5 FJUNQD=0.03 RINT=0 RVPOLY=0 DLSIL=0 RSH=0 RSHD=0 CFRW=0 RSHG=40 RGO=15 RBULKO=250 RWELLO=125 RJUNSO=250 RJUNDO=250 SWSOA=0 VGS_MAX=3 VGD_MAX=3 VGB_MAX=3 VDS_MAX=3 VDB_MAX=1.6 VSB_MAX=1.6
subckt dff (d q m clk qclk)
XSm (d mc clk) vswitch vt=2.5
Cm (mc 0) capacitor c=1e-14 ic=0
Em (m 0 mc 0) vcvs gain=1
XSs (m s qclk) vswitch
Cs (s 0) capacitor c=1e-14 ic=0
Eq (q 0 s 0) vcvs gain=1
ends dff
Vvp (vp 0) vsource dc=0 type=pwl wave=[ \
    0 0 1e-09 1.75 ]
Vvn (vn 0) vsource dc=0 type=pwl wave=[ \
    0 0 1e-09 1.55 ]
Vref (vref 0) vsource dc=0 type=pwl wave=[ \
    0 0 1e-09 1.65 ]
Vres (vres 0) vsource dc=0 type=pwl wave=[ \
    0 0 1e-09 1 ]
Vclk (clk 0) vsource dc=0 type=pulse val0=0 val1=3.3 delay=1.245e-07 rise=1e-09 fall=1e-09 width=1.24e-07 period=2.5e-07
Vqclk (qclk 0) vsource dc=0 type=pulse val0=0 val1=3.3 delay=2e-09 rise=1e-09 fall=1e-09 width=1.19e-07 period=2.5e-07
Vqclkb (qclkb 0) vsource dc=0 type=pulse val0=0 val1=3.3 delay=1.22e-07 rise=1e-09 fall=1e-09 width=1.29e-07 period=2.5e-07
Vclkb (clkb 0) vsource dc=0 type=pwl wave=[ \
    0 0 1e-09 3.3 1.245e-07 3.3 1.255e-07 0 2.495e-07 0 2.505e-07 3.3 \
    3.745e-07 3.3 3.755e-07 0 4.995e-07 0 5.005e-07 3.3 6.245e-07 3.3 6.255e-07 0 \
    7.495e-07 0 7.505e-07 3.3 8.745e-07 3.3 8.755e-07 0 9.995e-07 0 1.0005e-06 3.3 \
    1.1245e-06 3.3 1.1255e-06 0 1.2495e-06 0 1.2505e-06 3.3 1.3745e-06 3.3 1.3755e-06 0 \
    1.4995e-06 0 1.5005e-06 3.3 1.6245e-06 3.3 1.6255e-06 0 1.7495e-06 0 1.7505e-06 3.3 \
    1.8745e-06 3.3 1.8755e-06 0 1.9995e-06 0 2.0005e-06 3.3 2.1245e-06 3.3 2.1255e-06 0 \
    2.2495e-06 0 2.2505e-06 3.3 2.3745e-06 3.3 2.3755e-06 0 2.4995e-06 0 2.5005e-06 3.3 \
    2.6245e-06 3.3 2.6255e-06 0 2.7495e-06 0 2.7505e-06 3.3 2.8745e-06 3.3 2.8755e-06 0 \
    2.9995e-06 0 3.0005e-06 3.3 3.1245e-06 3.3 3.1255e-06 0 3.2495e-06 0 3.2505e-06 3.3 \
    3.3745e-06 3.3 3.3755e-06 0 3.4995e-06 0 3.5005e-06 3.3 3.6245e-06 3.3 3.6255e-06 0 \
    3.7495e-06 0 3.7505e-06 3.3 ]
Vdd (vdd 0) vsource dc=0 type=pwl wave=[ \
    0 0 1e-09 3.3 ]
Vth (vth 0) vsource dc=0 type=pwl wave=[ \
    0 0 1e-09 2.4 ]
Vbn (vbn 0) vsource dc=0 type=pwl wave=[ \
    0 0 1e-09 0.8 ]
Vvbp (vbp 0) vsource dc=0 type=pwl wave=[ \
    0 0 1e-09 1.8 ]
Vvbpc (vbpc 0) vsource dc=0 type=pwl wave=[ \
    0 0 1e-09 1.7 ]
Vvbnc (vbnc 0) vsource dc=0 type=pwl wave=[ \
    0 0 1e-09 1.2 ]
Vvbs (vbs 0) vsource dc=0 type=pwl wave=[ \
    0 0 1e-09 0.8703 ]
Vpor (por 0) vsource dc=0
Vwl1 (wl1 0) vsource dc=0 type=pulse val0=0 val1=3.3 delay=0 rise=1e-09 fall=1e-09 width=2.49e-07 period=1e-06
Vwl2 (wl2 0) vsource dc=0 type=pulse val0=0 val1=3.3 delay=2.5e-07 rise=1e-09 fall=1e-09 width=2.49e-07 period=1e-06
Vwl3 (wl3 0) vsource dc=0 type=pulse val0=0 val1=3.3 delay=5e-07 rise=1e-09 fall=1e-09 width=2.49e-07 period=1e-06
Vwl4 (wl4 0) vsource dc=0 type=pwl wave=[ \
    0 0 7.5e-07 0 7.51e-07 3.3 1e-06 3.3 1.001e-06 0 1.75e-06 0 \
    1.751e-06 3.3 2e-06 3.3 2.001e-06 0 2.75e-06 0 2.751e-06 3.3 3e-06 3.3 \
    3.001e-06 0 3.75e-06 0 ]
XGp1 (vp p1) rram level=0
XAp1 (p1 wl1 sl 0) hvn_w10000n_l450n_ng1 W=1e-05 L=4.5e-07 NF=1 MULT=1 AS=3.4e-12 AD=3.4e-12 PS=2.068e-05 PD=2.068e-05 NGCON=2 DELVTO=0 FACTUO=1
XGn1 (vn n1) rram level=2
XAn1 (n1 wl1 sl 0) hvn_w10000n_l450n_ng1 W=1e-05 L=4.5e-07 NF=1 MULT=1 AS=3.4e-12 AD=3.4e-12 PS=2.068e-05 PD=2.068e-05 NGCON=2 DELVTO=0 FACTUO=1
XGp2 (vp p2) rram level=1
XAp2 (p2 wl2 sl 0) hvn_w10000n_l450n_ng1 W=1e-05 L=4.5e-07 NF=1 MULT=1 AS=3.4e-12 AD=3.4e-12 PS=2.068e-05 PD=2.068e-05 NGCON=2 DELVTO=0 FACTUO=1
XGn2 (vn n2) rram level=3
XAn2 (n2 wl2 sl 0) hvn_w10000n_l450n_ng1 W=1e-05 L=4.5e-07 NF=1 MULT=1 AS=3.4e-12 AD=3.4e-12 PS=2.068e-05 PD=2.068e-05 NGCON=2 DELVTO=0 FACTUO=1
XGp3 (vp p3) rram level=2
XAp3 (p3 wl3 sl 0) hvn_w10000n_l450n_ng1 W=1e-05 L=4.5e-07 NF=1 MULT=1 AS=3.4e-12 AD=3.4e-12 PS=2.068e-05 PD=2.068e-05 NGCON=2 DELVTO=0 FACTUO=1
XGn3 (vn n3) rram level=1
XAn3 (n3 wl3 sl 0) hvn_w10000n_l450n_ng1 W=1e-05 L=4.5e-07 NF=1 MULT=1 AS=3.4e-12 AD=3.4e-12 PS=2.068e-05 PD=2.068e-05 NGCON=2 DELVTO=0 FACTUO=1
XGp4 (vp p4) rram level=1
XAp4 (p4 wl4 sl 0) hvn_w10000n_l450n_ng1 W=1e-05 L=4.5e-07 NF=1 MULT=1 AS=3.4e-12 AD=3.4e-12 PS=2.068e-05 PD=2.068e-05 NGCON=2 DELVTO=0 FACTUO=1
XGn4 (vn n4) rram level=2
XAn4 (n4 wl4 sl 0) hvn_w10000n_l450n_ng1 W=1e-05 L=4.5e-07 NF=1 MULT=1 AS=3.4e-12 AD=3.4e-12 PS=2.068e-05 PD=2.068e-05 NGCON=2 DELVTO=0 FACTUO=1
Xis_M1 (is_a1 sl is_tail 0) hvn_w4000n_l1000n_ng1 W=4e-06 L=1e-06 NF=1 MULT=1 AS=1.36e-12 AD=1.36e-12 PS=8.68e-06 PD=8.68e-06 NGCON=2 DELVTO=0 FACTUO=1
Xis_M2 (is_o1 vref is_tail 0) hvn_w4000n_l1000n_ng1 W=4e-06 L=1e-06 NF=1 MULT=1 AS=1.36e-12 AD=1.36e-12 PS=8.68e-06 PD=8.68e-06 NGCON=2 DELVTO=0 FACTUO=1
Xis_M3 (is_a1 is_a1 vdd vdd) hvp_w4000n_l1000n_ng1 W=4e-06 L=1e-06 NF=1 MULT=1 AS=1.36e-12 AD=1.36e-12 PS=8.68e-06 PD=8.68e-06 NGCON=2 DELVTO=0 FACTUO=1
Xis_M4 (is_o1 is_a1 vdd vdd) hvp_w4000n_l1000n_ng1 W=4e-06 L=1e-06 NF=1 MULT=1 AS=1.36e-12 AD=1.36e-12 PS=8.68e-06 PD=8.68e-06 NGCON=2 DELVTO=0 FACTUO=1
Xis_M5 (is_tail vbn 0 0) hvn_w2000n_l1000n_ng1 W=2e-06 L=1e-06 NF=1 MULT=1 AS=6.8e-13 AD=6.8e-13 PS=4.68e-06 PD=4.68e-06 NGCON=2 DELVTO=0 FACTUO=1
Xis_M6 (is_g is_o1 vdd vdd) hvp_w8000n_l1000n_ng1 W=8e-06 L=1e-06 NF=1 MULT=1 AS=2.72e-12 AD=2.72e-12 PS=1.668e-05 PD=1.668e-05 NGCON=2 DELVTO=0 FACTUO=1
Xis_M7 (is_g vbn 0 0) hvn_w2000n_l1000n_ng1 W=2e-06 L=1e-06 NF=1 MULT=1 AS=6.8e-13 AD=6.8e-13 PS=4.68e-06 PD=4.68e-06 NGCON=2 DELVTO=0 FACTUO=1
Cis_cc (is_o1 is_g) capacitor c=2e-13
Xis_Mib (sl vbp vdd vdd) hvp_w4000n_l2000n_ng1 W=4e-06 L=2e-06 NF=1 MULT=1 AS=1.36e-12 AD=1.36e-12 PS=8.68e-06 PD=8.68e-06 NGCON=2 DELVTO=0 FACTUO=1
Xis_Mcv (is_nd is_g sl vdd) hvp_w10000n_l400n_ng1 W=1e-05 L=4e-07 NF=1 MULT=1 AS=3.4e-12 AD=3.4e-12 PS=2.068e-05 PD=2.068e-05 NGCON=2 DELVTO=0 FACTUO=1
Xis_Mn1 (is_nd is_nd 0 0) hvn_w12000n_l2000n_ng2 W=1.2e-05 L=2e-06 NF=2 MULT=1 AS=4.08e-12 AD=2.28e-12 PS=2.536e-05 PD=1.276e-05 NGCON=2 DELVTO=0 FACTUO=1
Xis_Mn2 (is_pd is_nd 0 0) hvn_w12000n_l2000n_ng2 W=1.2e-05 L=2e-06 NF=2 MULT=1 AS=4.08e-12 AD=2.28e-12 PS=2.536e-05 PD=1.276e-05 NGCON=2 DELVTO=0 FACTUO=1
Xis_Mp1 (is_pd is_pd vdd vdd) hvp_w24000n_l2000n_ng3 W=2.4e-05 L=2e-06 NF=3 MULT=1 AS=5.76e-12 AD=5.76e-12 PS=3.344e-05 PD=3.344e-05 NGCON=2 DELVTO=0 FACTUO=1
Xis_Mp2 (is_pc is_pd vdd vdd) hvp_w34527n_l2000n_ng4 W=3.45271e-05 L=2e-06 NF=4 MULT=1 AS=9.14968e-12 AD=6.56015e-12 PS=5.39106e-05 PD=3.60471e-05 NGCON=2 DELVTO=0 FACTUO=1
Xis_Mp2c (is_o vbpc is_pc vdd) hvp_w11509n_l400n_ng2 W=1.1509e-05 L=4e-07 NF=2 MULT=1 AS=3.91307e-12 AD=2.18672e-12 PS=2.43781e-05 PD=1.2269e-05 NGCON=2 DELVTO=0 FACTUO=1
Xis_Msubc (is_o vbnc is_sc 0) hvn_w5755n_l450n_ng1 W=5.75451e-06 L=4.5e-07 NF=1 MULT=1 AS=1.95654e-12 AD=1.95654e-12 PS=1.2189e-05 PD=1.2189e-05 NGCON=2 DELVTO=0 FACTUO=1
Xis_Msub (is_sc vbs 0 0) hvn_w17264n_l2000n_ng2 W=1.72635e-05 L=2e-06 NF=2 MULT=1 AS=5.86961e-12 AD=3.28007e-12 PS=3.58871e-05 PD=1.80235e-05 NGCON=2 DELVTO=0 FACTUO=1
Xis_Mb1 (is_b1 vm is_bt vdd) hvp_w2000n_l500n_ng1 W=2e-06 L=5e-07 NF=1 MULT=1 AS=6.8e-13 AD=6.8e-13 PS=4.68e-06 PD=4.68e-06 NGCON=2 DELVTO=0 FACTUO=1
Xis_Mb2 (is_dump is_dump is_bt vdd) hvp_w2000n_l500n_ng1 W=2e-06 L=5e-07 NF=1 MULT=1 AS=6.8e-13 AD=6.8e-13 PS=4.68e-06 PD=4.68e-06 NGCON=2 DELVTO=0 FACTUO=1
Xis_Mb3 (is_b1 is_b1 0 0) hvn_w4000n_l1000n_ng1 W=4e-06 L=1e-06 NF=1 MULT=1 AS=1.36e-12 AD=1.36e-12 PS=8.68e-06 PD=8.68e-06 NGCON=2 DELVTO=0 FACTUO=1
Xis_Mb4 (is_dump is_b1 0 0) hvn_w4000n_l1000n_ng1 W=4e-06 L=1e-06 NF=1 MULT=1 AS=1.36e-12 AD=1.36e-12 PS=8.68e-06 PD=8.68e-06 NGCON=2 DELVTO=0 FACTUO=1
Xis_Mb5 (is_bt vbp vdd vdd) hvp_w8000n_l2000n_ng1 W=8e-06 L=2e-06 NF=1 MULT=1 AS=2.72e-12 AD=2.72e-12 PS=1.668e-05 PD=1.668e-05 NGCON=2 DELVTO=0 FACTUO=1
Xis_Ms1 (is_o clk vm 0) hvn_w2000n_l450n_ng1 W=2e-06 L=4.5e-07 NF=1 MULT=1 AS=6.8e-13 AD=6.8e-13 PS=4.68e-06 PD=4.68e-06 NGCON=2 DELVTO=0 FACTUO=1
Xis_Ms2 (is_o clkb vm vdd) hvp_w4000n_l400n_ng1 W=4e-06 L=4e-07 NF=1 MULT=1 AS=1.36e-12 AD=1.36e-12 PS=8.68e-06 PD=8.68e-06 NGCON=2 DELVTO=0 FACTUO=1
Xis_Ms3 (is_o clkb is_dump 0) hvn_w2000n_l450n_ng1 W=2e-06 L=4.5e-07 NF=1 MULT=1 AS=6.8e-13 AD=6.8e-13 PS=4.68e-06 PD=4.68e-06 NGCON=2 DELVTO=0 FACTUO=1
Xis_Ms4 (is_o clk is_dump vdd) hvp_w4000n_l400n_ng1 W=4e-06 L=4e-07 NF=1 MULT=1 AS=1.36e-12 AD=1.36e-12 PS=8.68e-06 PD=8.68e-06 NGCON=2 DELVTO=0 FACTUO=1
CM (vm 0) capacitor c=9.98e-13 ic=0
CL (cl 0) capacitor c=6.6e-13 ic=0
XMlkn (vm qclk cl 0) hvn_w2000n_l450n_ng1 W=2e-06 L=4.5e-07 NF=1 MULT=1 AS=6.8e-13 AD=6.8e-13 PS=4.68e-06 PD=4.68e-06 NGCON=2 DELVTO=0 FACTUO=1
XMlkp (vm qclkb cl vdd) hvp_w4000n_l400n_ng1 W=4e-06 L=4e-07 NF=1 MULT=1 AS=1.36e-12 AD=1.36e-12 PS=8.68e-06 PD=8.68e-06 NGCON=2 DELVTO=0 FACTUO=1
XMdis (cl clk 0 0) hvn_w2000n_l450n_ng1 W=2e-06 L=4.5e-07 NF=1 MULT=1 AS=6.8e-13 AD=6.8e-13 PS=4.68e-06 PD=4.68e-06 NGCON=2 DELVTO=0 FACTUO=1
XMc1 (cd1 vm ctail 0) hvn_w4000n_l1000n_ng1 W=4e-06 L=1e-06 NF=1 MULT=1 AS=1.36e-12 AD=1.36e-12 PS=8.68e-06 PD=8.68e-06 NGCON=2 DELVTO=0 FACTUO=1
XMc2 (co1 vth ctail 0) hvn_w4000n_l1000n_ng1 W=4e-06 L=1e-06 NF=1 MULT=1 AS=1.36e-12 AD=1.36e-12 PS=8.68e-06 PD=8.68e-06 NGCON=2 DELVTO=0 FACTUO=1
XMc3 (cd1 cd1 vdd vdd) hvp_w4000n_l1000n_ng1 W=4e-06 L=1e-06 NF=1 MULT=1 AS=1.36e-12 AD=1.36e-12 PS=8.68e-06 PD=8.68e-06 NGCON=2 DELVTO=0 FACTUO=1
XMc4 (co1 cd1 vdd vdd) hvp_w4000n_l1000n_ng1 W=4e-06 L=1e-06 NF=1 MULT=1 AS=1.36e-12 AD=1.36e-12 PS=8.68e-06 PD=8.68e-06 NGCON=2 DELVTO=0 FACTUO=1
XMc5 (ctail vbn 0 0) hvn_w2000n_l1000n_ng1 W=2e-06 L=1e-06 NF=1 MULT=1 AS=6.8e-13 AD=6.8e-13 PS=4.68e-06 PD=4.68e-06 NGCON=2 DELVTO=0 FACTUO=1
XMci1n (cmpb co1 0 0) hvn_w1000n_l450n_ng1 W=1e-06 L=4.5e-07 NF=1 MULT=1 AS=3.4e-13 AD=3.4e-13 PS=2.68e-06 PD=2.68e-06 NGCON=2 DELVTO=0 FACTUO=1
XMci1p (cmpb co1 vdd vdd) hvp_w2000n_l400n_ng1 W=2e-06 L=4e-07 NF=1 MULT=1 AS=6.8e-13 AD=6.8e-13 PS=4.68e-06 PD=4.68e-06 NGCON=2 DELVTO=0 FACTUO=1
XMci2n (cmp cmpb 0 0) hvn_w1000n_l450n_ng1 W=1e-06 L=4.5e-07 NF=1 MULT=1 AS=3.4e-13 AD=3.4e-13 PS=2.68e-06 PD=2.68e-06 NGCON=2 DELVTO=0 FACTUO=1
XMci2p (cmp cmpb vdd vdd) hvp_w2000n_l400n_ng1 W=2e-06 L=4e-07 NF=1 MULT=1 AS=6.8e-13 AD=6.8e-13 PS=4.68e-06 PD=4.68e-06 NGCON=2 DELVTO=0 FACTUO=1
XMfm1 (cmp clk fmc 0) hvn_w1000n_l450n_ng1 W=1e-06 L=4.5e-07 NF=1 MULT=1 AS=3.4e-13 AD=3.4e-13 PS=2.68e-06 PD=2.68e-06 NGCON=2 DELVTO=0 FACTUO=1
XMfm2 (cmp clkb fmc vdd) hvp_w2000n_l400n_ng1 W=2e-06 L=4e-07 NF=1 MULT=1 AS=6.8e-13 AD=6.8e-13 PS=4.68e-06 PD=4.68e-06 NGCON=2 DELVTO=0 FACTUO=1
Cfm (fmc 0) capacitor c=1e-14 ic=0
XMfmi1n (fmb fmc 0 0) hvn_w1000n_l450n_ng1 W=1e-06 L=4.5e-07 NF=1 MULT=1 AS=3.4e-13 AD=3.4e-13 PS=2.68e-06 PD=2.68e-06 NGCON=2 DELVTO=0 FACTUO=1
XMfmi1p (fmb fmc vdd vdd) hvp_w2000n_l400n_ng1 W=2e-06 L=4e-07 NF=1 MULT=1 AS=6.8e-13 AD=6.8e-13 PS=4.68e-06 PD=4.68e-06 NGCON=2 DELVTO=0 FACTUO=1
XMfmi2n (m0 fmb 0 0) hvn_w1000n_l450n_ng1 W=1e-06 L=4.5e-07 NF=1 MULT=1 AS=3.4e-13 AD=3.4e-13 PS=2.68e-06 PD=2.68e-06 NGCON=2 DELVTO=0 FACTUO=1
XMfmi2p (m0 fmb vdd vdd) hvp_w2000n_l400n_ng1 W=2e-06 L=4e-07 NF=1 MULT=1 AS=6.8e-13 AD=6.8e-13 PS=4.68e-06 PD=4.68e-06 NGCON=2 DELVTO=0 FACTUO=1
XMfs1 (m0 qclk fsc 0) hvn_w1000n_l450n_ng1 W=1e-06 L=4.5e-07 NF=1 MULT=1 AS=3.4e-13 AD=3.4e-13 PS=2.68e-06 PD=2.68e-06 NGCON=2 DELVTO=0 FACTUO=1
XMfs2 (m0 qclkb fsc vdd) hvp_w2000n_l400n_ng1 W=2e-06 L=4e-07 NF=1 MULT=1 AS=6.8e-13 AD=6.8e-13 PS=4.68e-06 PD=4.68e-06 NGCON=2 DELVTO=0 FACTUO=1
Cfs (fsc 0) capacitor c=1e-14 ic=0
XMfsi1n (fsb fsc 0 0) hvn_w1000n_l450n_ng1 W=1e-06 L=4.5e-07 NF=1 MULT=1 AS=3.4e-13 AD=3.4e-13 PS=2.68e-06 PD=2.68e-06 NGCON=2 DELVTO=0 FACTUO=1
XMfsi1p (fsb fsc vdd vdd) hvp_w2000n_l400n_ng1 W=2e-06 L=4e-07 NF=1 MULT=1 AS=6.8e-13 AD=6.8e-13 PS=4.68e-06 PD=4.68e-06 NGCON=2 DELVTO=0 FACTUO=1
XMfsi2n (q0 fsb 0 0) hvn_w1000n_l450n_ng1 W=1e-06 L=4.5e-07 NF=1 MULT=1 AS=3.4e-13 AD=3.4e-13 PS=2.68e-06 PD=2.68e-06 NGCON=2 DELVTO=0 FACTUO=1
XMfsi2p (q0 fsb vdd vdd) hvp_w2000n_l400n_ng1 W=2e-06 L=4e-07 NF=1 MULT=1 AS=6.8e-13 AD=6.8e-13 PS=4.68e-06 PD=4.68e-06 NGCON=2 DELVTO=0 FACTUO=1
Espk (spk 0 q0 0) vcvs gain=1
XMra1 (rsb m0 ra 0) hvn_w1000n_l450n_ng1 W=1e-06 L=4.5e-07 NF=1 MULT=1 AS=3.4e-13 AD=3.4e-13 PS=2.68e-06 PD=2.68e-06 NGCON=2 DELVTO=0 FACTUO=1
XMra2 (ra clkb 0 0) hvn_w1000n_l450n_ng1 W=1e-06 L=4.5e-07 NF=1 MULT=1 AS=3.4e-13 AD=3.4e-13 PS=2.68e-06 PD=2.68e-06 NGCON=2 DELVTO=0 FACTUO=1
XMrb1 (rsb q0 rb 0) hvn_w1000n_l450n_ng1 W=1e-06 L=4.5e-07 NF=1 MULT=1 AS=3.4e-13 AD=3.4e-13 PS=2.68e-06 PD=2.68e-06 NGCON=2 DELVTO=0 FACTUO=1
XMrb2 (rb clk 0 0) hvn_w1000n_l450n_ng1 W=1e-06 L=4.5e-07 NF=1 MULT=1 AS=3.4e-13 AD=3.4e-13 PS=2.68e-06 PD=2.68e-06 NGCON=2 DELVTO=0 FACTUO=1
XMrp1 (rp m0 vdd vdd) hvp_w2000n_l400n_ng1 W=2e-06 L=4e-07 NF=1 MULT=1 AS=6.8e-13 AD=6.8e-13 PS=4.68e-06 PD=4.68e-06 NGCON=2 DELVTO=0 FACTUO=1
XMrp2 (rp clkb vdd vdd) hvp_w2000n_l400n_ng1 W=2e-06 L=4e-07 NF=1 MULT=1 AS=6.8e-13 AD=6.8e-13 PS=4.68e-06 PD=4.68e-06 NGCON=2 DELVTO=0 FACTUO=1
XMrp3 (rsb q0 rp vdd) hvp_w2000n_l400n_ng1 W=2e-06 L=4e-07 NF=1 MULT=1 AS=6.8e-13 AD=6.8e-13 PS=4.68e-06 PD=4.68e-06 NGCON=2 DELVTO=0 FACTUO=1
XMrp4 (rsb clk rp vdd) hvp_w2000n_l400n_ng1 W=2e-06 L=4e-07 NF=1 MULT=1 AS=6.8e-13 AD=6.8e-13 PS=4.68e-06 PD=4.68e-06 NGCON=2 DELVTO=0 FACTUO=1
XMrin (rs rsb 0 0) hvn_w1000n_l450n_ng1 W=1e-06 L=4.5e-07 NF=1 MULT=1 AS=3.4e-13 AD=3.4e-13 PS=2.68e-06 PD=2.68e-06 NGCON=2 DELVTO=0 FACTUO=1
XMrip (rs rsb vdd vdd) hvp_w2000n_l400n_ng1 W=2e-06 L=4e-07 NF=1 MULT=1 AS=6.8e-13 AD=6.8e-13 PS=4.68e-06 PD=4.68e-06 NGCON=2 DELVTO=0 FACTUO=1
XMrst (vm rs vres 0) hvn_w2000n_l450n_ng1 W=2e-06 L=4.5e-07 NF=1 MULT=1 AS=6.8e-13 AD=6.8e-13 PS=4.68e-06 PD=4.68e-06 NGCON=2 DELVTO=0 FACTUO=1

save clk wl1 vm spk
tr tran stop=3.75e-06 step=5e-10 skipdc=yes
