// multiphysics__tec_pid -- Spectre translation of circuits/multiphysics/tec_pid.net (scripts/spectre_golden/net2spectre.py)
simulator lang=spectre
global 0
opts options reltol=1e-6 vabstol=1e-9 iabstol=1e-15 temp=27 tnom=27 gmin=1e-18 save=selected

ahdl_include "models/multiphysics/tec/tec.va"
ahdl_include "models/multiphysics/tec/pid.va"
ahdl_include "models/multiphysics/tec/thermal_parts.va"

XC (drv 0 plate sink) tec alpha0=0.05 alpha1=0.0001 R0=2 tcr=0.004 K=0.5
XP (plate drv) pid tset=278.15 kp=2 ki=0.2 kd=2 tf=0.5 kb=1 vmin=0 vmax=12 ton=5
XM1 (plate) thermal_mass C=20
XL (plate) heat_load p0=1 dp=2 tstep=60 trise=0.5
XM2 (sink) thermal_mass C=50
XR (sink amb) thermal_res Rth=0.5
XA (amb) ambient tamb=298.15

save cold hot drv
tr tran stop=150 step=0.5
