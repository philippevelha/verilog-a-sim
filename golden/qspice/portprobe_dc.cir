* QSPICE reference for circuits/portprobe_dc.net
V1 a 0 DC 1
R1 a 0 1000
C1 a 0 1u
B1 out 0 V=-I(V1)
.op
.end
